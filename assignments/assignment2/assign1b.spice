** sch_path: /home/joyen/ee5311/EE5311/assignments/assignment2/assign1b.sch
**.subckt assign1b
Vin Vin GND pulse(0 1.8 0 1ns 1ns 5ns 10ns)
XM1 Vout Vin VDD VDD sky130_fd_pr__pfet_01v8 L=0.15 W=11.99958 nf=1 ad='int((nf+1)/2) * W/nf * 0.29' as='int((nf+2)/2) * W/nf * 0.29'
+ pd='2*int((nf+1)/2) * (W/nf + 0.29)' ps='2*int((nf+2)/2) * (W/nf + 0.29)' nrd='0.29 / W' nrs='0.29 / W' sa=0 sb=0 sd=0 mult=1
XM2 Vout Vin GND GND sky130_fd_pr__nfet_01v8 L=0.15 W=0.42 nf=1 ad='int((nf+1)/2) * W/nf * 0.29' as='int((nf+2)/2) * W/nf * 0.29' pd='2*int((nf+1)/2) * (W/nf + 0.29)'
+ ps='2*int((nf+2)/2) * (W/nf + 0.29)' nrd='0.29 / W' nrs='0.29 / W' sa=0 sb=0 sd=0 mult=1
Vin1 VDD GND 1.8
**** begin user architecture code

* Control flag: 1 for DC Sweep / VTC, 2 for Transient Pulse
.control
  let sim_type = 1

  if sim_type = 1
    * Run DC Sweep for VTC and Noise Margins
    destroy all
    dc Vin 0 1.8 0.01
    run
    plot v(Vout) v(Vin) vs v(Vin)
    plot deriv(v(Vout))
  else
    * Run Transient Pulse Response
    destroy all
    tran 0.01ns 20ns
    run
    plot v(Vin) v(Vout) vs time
  end
.endc

.lib /cad/share/pdk/sky130B/libs.tech/combined/sky130.lib.spice tt
**** end user architecture code
**.ends
.GLOBAL GND
.GLOBAL VDD
.end
