** sch_path: /home/joyen/ee5311/EE5311/assignments/assignment3/assign2a.sch
**.subckt assign2a
x1 net1 vout inverter
x2 net2 net1 inverter
x3 net3 net2 inverter
x4 net4 net3 inverter
x5 net5 net4 inverter
x6 net6 net5 inverter
x7 vout net6 inverter
V1 VDD GND 1.8
**** begin user architecture code

.param VDDVal = 1.8
.param width_p = 0.84

* Force Vout to 0V at t=0 to kickstart the oscillation
.ic v(vout)=0

.control
* Run transient analysis for 5ns.
tran 1p 5n uic

* CORRECTED: Use 'WHEN' to grab the exact timestamp of the edges
meas tran t1 WHEN v(vout)=0.9 rise=3
meas tran t2 WHEN v(vout)=0.9 rise=4

* Calculate period and frequency (Frequency = 1 / Period)
let period = t2 - t1
let freq = 1 / period

* Print the results to the terminal
print period
print freq

* Plot the oscillating waveform
plot v(vout)
.endc

.lib /cad/share/pdk/sky130B/libs.tech/combined/sky130.lib.spice tt
**** end user architecture code
**.ends

* expanding   symbol:  inverter.sym # of pins=2
** sym_path: /home/joyen/ee5311/EE5311/assignments/assignment3/inverter.sym
** sch_path: /home/joyen/ee5311/EE5311/assignments/assignment3/inverter.sch
.subckt inverter y a
*.ipin a
*.opin y
XM1 y a GND GND sky130_fd_pr__nfet_01v8 L=0.15 W=0.42 nf=1 ad='int((nf+1)/2) * W/nf * 0.29' as='int((nf+2)/2) * W/nf * 0.29' pd='2*int((nf+1)/2) * (W/nf + 0.29)'
+ ps='2*int((nf+2)/2) * (W/nf + 0.29)' nrd='0.29 / W' nrs='0.29 / W' sa=0 sb=0 sd=0 mult=1
XM2 y a VDD VDD sky130_fd_pr__pfet_01v8 L=0.15 W={width_p} nf=1 ad='int((nf+1)/2) * W/nf * 0.29' as='int((nf+2)/2) * W/nf * 0.29' pd='2*int((nf+1)/2) * (W/nf + 0.29)'
+ ps='2*int((nf+2)/2) * (W/nf + 0.29)' nrd='0.29 / W' nrs='0.29 / W' sa=0 sb=0 sd=0 mult=1
.ends

.GLOBAL VDD
.GLOBAL GND
.end
