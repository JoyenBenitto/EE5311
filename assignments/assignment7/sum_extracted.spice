* NGSPICE file created from sum_flat.ext - technology: sky130A

.subckt sum_flat coutbar sout
X0 coutbar coutbar coutbar VSUBS sky130_fd_pr__nfet_01v8 ad=0.1218 pd=1.42 as=1.7052 ps=19.88 w=0.42 l=0.15
X1 coutbar coutbar coutbar VSUBS sky130_fd_pr__nfet_01v8 ad=0.1218 pd=1.42 as=0 ps=0 w=0.42 l=0.15
X2 coutbar coutbar coutbar w_1141_1240# sky130_fd_pr__pfet_01v8 ad=0.1218 pd=1.42 as=1.7052 ps=19.88 w=0.42 l=0.15
X3 coutbar coutbar coutbar w_1391_1240# sky130_fd_pr__pfet_01v8 ad=0.1218 pd=1.42 as=0 ps=0 w=0.42 l=0.15
X4 coutbar coutbar coutbar VSUBS sky130_fd_pr__nfet_01v8 ad=0.1218 pd=1.42 as=0 ps=0 w=0.42 l=0.15
X5 coutbar coutbar coutbar w_641_1240# sky130_fd_pr__pfet_01v8 ad=0.1218 pd=1.42 as=0 ps=0 w=0.42 l=0.15
X6 coutbar coutbar coutbar w_891_1240# sky130_fd_pr__pfet_01v8 ad=0.1218 pd=1.42 as=0 ps=0 w=0.42 l=0.15
X7 coutbar coutbar coutbar VSUBS sky130_fd_pr__nfet_01v8 ad=0.1218 pd=1.42 as=0 ps=0 w=0.42 l=0.15
X8 coutbar coutbar coutbar w_141_1240# sky130_fd_pr__pfet_01v8 ad=0.1218 pd=1.42 as=0 ps=0 w=0.42 l=0.15
X9 coutbar coutbar coutbar w_391_1240# sky130_fd_pr__pfet_01v8 ad=0.1218 pd=1.42 as=0 ps=0 w=0.42 l=0.15
X10 coutbar coutbar coutbar VSUBS sky130_fd_pr__nfet_01v8 ad=0.1218 pd=1.42 as=0 ps=0 w=0.42 l=0.15
X11 coutbar coutbar coutbar w_n109_1240# sky130_fd_pr__pfet_01v8 ad=0.1218 pd=1.42 as=0 ps=0 w=0.42 l=0.15
X12 coutbar coutbar coutbar VSUBS sky130_fd_pr__nfet_01v8 ad=0.1218 pd=1.42 as=0 ps=0 w=0.42 l=0.15
X13 coutbar coutbar coutbar VSUBS sky130_fd_pr__nfet_01v8 ad=0.1218 pd=1.42 as=0 ps=0 w=0.42 l=0.15
.ends
