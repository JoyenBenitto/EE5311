** sch_path: /home/joyen/ee5311/EE5311/assignments/assignment7/sum_tb.sch
**.subckt sum_tb
x1 VDD a b gnd c sum_bar gnd sum
vdd VDD gnd 1.8
va a gnd 1.8
va1 b gnd 0
va2 c gnd 0
**** begin user architecture code

.include sum_extracted.spice
.control
*alter @va[pulse] = [ 1.8 0 10p 5p 5p]
*alter @va1[pulse] = [ 0 1.8 10p 5p 5p]
*alter @va2[pulse] = [ 1.8 0 10p 5p 5p]

tran 1p 400p

plot v(a) v(b) v(c) v(sum_bar)
print v(sum_bar)
.endc

.lib /cad/share/pdk/sky130B/libs.tech/combined/sky130.lib.spice tt
**** end user architecture code
**.ends
.GLOBAL VDD
.GLOBAL gnd
.end
