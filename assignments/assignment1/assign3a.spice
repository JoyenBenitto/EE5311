** sch_path: /home/joyen/ee5311/workdir/EE5311/assignments/assignment1/assign3a.sch
**.subckt assign3a
XM1 net2 net1 net3 GND sky130_fd_pr__nfet_01v8 L=0.15 W=0.42 nf=1 ad='int((nf+1)/2) * W/nf * 0.29' as='int((nf+2)/2) * W/nf * 0.29'
+ pd='2*int((nf+1)/2) * (W/nf + 0.29)' ps='2*int((nf+2)/2) * (W/nf + 0.29)' nrd='0.29 / W' nrs='0.29 / W' sa=0 sb=0 sd=0 mult=1
Vgs net1 GND 1.8
Vds net2 GND 1.8
C1 net3 GND 100p
**** begin user architecture code

.include sim3b.cir

.lib /cad/share/pdk/sky130B/libs.tech/combined/sky130.lib.spice tt
**** end user architecture code
**.ends
.GLOBAL GND
.end
