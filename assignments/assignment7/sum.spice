** sch_path: /home/joyen/ee5311/EE5311/assignments/assignment7/sum.sch
.subckt sum VDD a b coutbar cin sout GND
*.PININFO sout:O a:I VDD:B GND:B b:I coutbar:I cin:I
XM1 sout coutbar net4 GND sky130_fd_pr__nfet_01v8 L=0.15 W=0.42 nf=1
XM2 net1 b VDD VDD sky130_fd_pr__pfet_01v8 L=0.15 W=0.42 nf=1
XM4 sout coutbar net1 VDD sky130_fd_pr__pfet_01v8 L=0.15 W=0.42 nf=1
XM5 net1 a VDD VDD sky130_fd_pr__pfet_01v8 L=0.15 W=0.42 nf=1
XM6 net1 cin VDD VDD sky130_fd_pr__pfet_01v8 L=0.15 W=0.42 nf=1
XM7 net3 a VDD VDD sky130_fd_pr__pfet_01v8 L=0.15 W=0.42 nf=1
XM3 net2 b net3 VDD sky130_fd_pr__pfet_01v8 L=0.15 W=0.42 nf=1
XM8 sout cin net2 VDD sky130_fd_pr__pfet_01v8 L=0.15 W=0.42 nf=1
XM9 net4 a GND GND sky130_fd_pr__nfet_01v8 L=0.15 W=0.42 nf=1
XM10 net4 b GND GND sky130_fd_pr__nfet_01v8 L=0.15 W=0.42 nf=1
XM11 net4 cin GND GND sky130_fd_pr__nfet_01v8 L=0.15 W=0.42 nf=1
XM12 sout cin net6 GND sky130_fd_pr__nfet_01v8 L=0.15 W=0.42 nf=1
XM13 net6 b net5 GND sky130_fd_pr__nfet_01v8 L=0.15 W=0.42 nf=1
XM14 net5 a GND GND sky130_fd_pr__nfet_01v8 L=0.15 W=0.42 nf=1
.ends
