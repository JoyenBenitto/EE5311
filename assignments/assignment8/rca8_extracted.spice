* NGSPICE file created from rca8.ext - technology: sky130A

.subckt rca8 cout7 cin0 b2 a2 b3 a3 b4 a4 b5 a5 b6 a6 b7 a7 b0 a0 b1 a1 sout0 sout1
+ sout2 sout3 sout4 sout5 sout6 sout7 GND VDD
X0 GND b6 a_n1027_4456# GND sky130_fd_pr__nfet_01v8 ad=0.105 pd=0.92 as=0.126 ps=1.44 w=0.42 l=0.15
X1 VDD a1 a_n1730_850# VDD sky130_fd_pr__pfet_01v8 ad=0.252 pd=2.28 as=0.21 ps=1.34 w=0.84 l=0.15
X2 VDD a5 a_n1730_3996# VDD sky130_fd_pr__pfet_01v8 ad=0.252 pd=2.28 as=0.21 ps=1.34 w=0.84 l=0.15
X3 GND a6 a_n3317_4511# GND sky130_fd_pr__nfet_01v8 ad=0.126 pd=1.44 as=0.105 ps=0.92 w=0.42 l=0.15
X4 a_n2911_2155# b3 GND GND sky130_fd_pr__nfet_01v8 ad=0.105 pd=0.92 as=0.105 ps=0.92 w=0.42 l=0.15
X5 GND a1 a_n1027_522# GND sky130_fd_pr__nfet_01v8 ad=0.105 pd=0.92 as=0.105 ps=0.92 w=0.42 l=0.15
X6 GND a1 a_n1749_522# GND sky130_fd_pr__nfet_01v8 ad=0.126 pd=1.44 as=0.105 ps=0.92 w=0.42 l=0.15
X7 GND a1 a_n2911_578# GND sky130_fd_pr__nfet_01v8 ad=0.105 pd=0.92 as=0.105 ps=0.92 w=0.42 l=0.15
X8 a_n3317_929# b1 a_n3447_929# VDD sky130_fd_pr__pfet_01v8 ad=0.105 pd=0.92 as=0.105 ps=0.92 w=0.42 l=0.15
X9 VDD a6 a_n3317_4863# VDD sky130_fd_pr__pfet_01v8 ad=0.126 pd=1.44 as=0.105 ps=0.92 w=0.42 l=0.15
X10 GND a4 a_n2911_2909# GND sky130_fd_pr__nfet_01v8 ad=0.105 pd=0.92 as=0.105 ps=0.92 w=0.42 l=0.15
X11 a_n1749_1311# b2 a_n3634_2342# GND sky130_fd_pr__nfet_01v8 ad=0.126 pd=1.44 as=0.105 ps=0.92 w=0.42 l=0.15
X12 GND a_n3634_4699# a_n2911_4512# GND sky130_fd_pr__nfet_01v8 ad=0.126 pd=1.44 as=0.105 ps=0.92 w=0.42 l=0.15
X13 VDD a5 a_n2911_4075# VDD sky130_fd_pr__pfet_01v8 ad=0.105 pd=0.92 as=0.105 ps=0.92 w=0.42 l=0.15
X14 a_n3634_1554# b1 a_n1730_850# VDD sky130_fd_pr__pfet_01v8 ad=0.21 pd=1.34 as=0.252 ps=2.28 w=0.84 l=0.15
X15 cout7 b7 a_n1730_5538# VDD sky130_fd_pr__pfet_01v8 ad=0.21 pd=1.34 as=0.252 ps=2.28 w=0.84 l=0.15
X16 a_n1027_5210# a_n3634_5453# cout7 GND sky130_fd_pr__nfet_01v8 ad=0.126 pd=1.44 as=0.105 ps=0.92 w=0.42 l=0.15
X17 a_n3634_3096# b3 a_n1749_2099# GND sky130_fd_pr__nfet_01v8 ad=0.105 pd=0.92 as=0.126 ps=1.44 w=0.42 l=0.15
X18 a_n2911_4863# a_n3634_5453# sout6 VDD sky130_fd_pr__pfet_01v8 ad=0.105 pd=0.92 as=0.126 ps=1.44 w=0.42 l=0.15
X19 VDD a3 a_n2911_2506# VDD sky130_fd_pr__pfet_01v8 ad=0.105 pd=0.92 as=0.105 ps=0.92 w=0.42 l=0.15
X20 a_n1008_1639# b2 VDD VDD sky130_fd_pr__pfet_01v8 ad=0.21 pd=1.34 as=0.21 ps=1.34 w=0.84 l=0.15
X21 a_n2911_5617# b7 VDD VDD sky130_fd_pr__pfet_01v8 ad=0.105 pd=0.92 as=0.105 ps=0.92 w=0.42 l=0.15
X22 a_n1730_4784# a6 VDD VDD sky130_fd_pr__pfet_01v8 ad=0.21 pd=1.34 as=0.252 ps=2.28 w=0.84 l=0.15
X23 VDD b5 a_n1008_3996# VDD sky130_fd_pr__pfet_01v8 ad=0.21 pd=1.34 as=0.252 ps=2.28 w=0.84 l=0.15
X24 VDD a4 a_n2911_3260# VDD sky130_fd_pr__pfet_01v8 ad=0.105 pd=0.92 as=0.105 ps=0.92 w=0.42 l=0.15
X25 VDD a3 a_n1730_2427# VDD sky130_fd_pr__pfet_01v8 ad=0.252 pd=2.28 as=0.21 ps=1.34 w=0.84 l=0.15
X26 a_n1027_3668# a_n3634_3911# a_n3634_4699# GND sky130_fd_pr__nfet_01v8 ad=0.126 pd=1.44 as=0.105 ps=0.92 w=0.42 l=0.15
X27 VDD a4 a_n1730_3181# VDD sky130_fd_pr__pfet_01v8 ad=0.252 pd=2.28 as=0.21 ps=1.34 w=0.84 l=0.15
X28 a_n1027_522# a1 GND GND sky130_fd_pr__nfet_01v8 ad=0.126 pd=1.44 as=0.105 ps=0.92 w=0.42 l=0.15
X29 a_n3634_1554# b1 a_n1749_522# GND sky130_fd_pr__nfet_01v8 ad=0.105 pd=0.92 as=0.126 ps=1.44 w=0.42 l=0.15
X30 a_n1027_1311# b2 GND GND sky130_fd_pr__nfet_01v8 ad=0.105 pd=0.92 as=0.105 ps=0.92 w=0.42 l=0.15
X31 VDD a1 a_n3317_929# VDD sky130_fd_pr__pfet_01v8 ad=0.126 pd=1.44 as=0.105 ps=0.92 w=0.42 l=0.15
X32 a_n2911_5266# cout7 sout7 GND sky130_fd_pr__nfet_01v8 ad=0.105 pd=0.92 as=0.126 ps=1.44 w=0.42 l=0.15
X33 a_n1749_4456# b6 a_n3634_5453# GND sky130_fd_pr__nfet_01v8 ad=0.126 pd=1.44 as=0.105 ps=0.92 w=0.42 l=0.15
X34 GND b3 a_n1027_2099# GND sky130_fd_pr__nfet_01v8 ad=0.105 pd=0.92 as=0.126 ps=1.44 w=0.42 l=0.15
X35 a_n3447_141# cin0 sout0 VDD sky130_fd_pr__pfet_01v8 ad=0.105 pd=0.92 as=0.126 ps=1.44 w=0.42 l=0.15
X36 a_n3634_2342# a_n3634_1554# a_n1027_1311# GND sky130_fd_pr__nfet_01v8 ad=0.105 pd=0.92 as=0.126 ps=1.44 w=0.42 l=0.15
X37 a_n1027_2853# a_n3634_3096# a_n3634_3911# GND sky130_fd_pr__nfet_01v8 ad=0.126 pd=1.44 as=0.105 ps=0.92 w=0.42 l=0.15
X38 GND a3 a_n3317_2154# GND sky130_fd_pr__nfet_01v8 ad=0.126 pd=1.44 as=0.105 ps=0.92 w=0.42 l=0.15
X39 a_n1730_850# b1 a_n3634_1554# VDD sky130_fd_pr__pfet_01v8 ad=0.252 pd=2.28 as=0.21 ps=1.34 w=0.84 l=0.15
X40 a_n1027_4456# b6 GND GND sky130_fd_pr__nfet_01v8 ad=0.105 pd=0.92 as=0.105 ps=0.92 w=0.42 l=0.15
X41 VDD b3 a_n1008_2427# VDD sky130_fd_pr__pfet_01v8 ad=0.21 pd=1.34 as=0.252 ps=2.28 w=0.84 l=0.15
X42 GND b1 a_n1027_522# GND sky130_fd_pr__nfet_01v8 ad=0.105 pd=0.92 as=0.126 ps=1.44 w=0.42 l=0.15
X43 a_n1749_522# b1 a_n3634_1554# GND sky130_fd_pr__nfet_01v8 ad=0.126 pd=1.44 as=0.105 ps=0.92 w=0.42 l=0.15
X44 a_n3634_5453# a_n3634_4699# a_n1027_4456# GND sky130_fd_pr__nfet_01v8 ad=0.105 pd=0.92 as=0.126 ps=1.44 w=0.42 l=0.15
X45 VDD b4 a_n1008_3181# VDD sky130_fd_pr__pfet_01v8 ad=0.21 pd=1.34 as=0.252 ps=2.28 w=0.84 l=0.15
X46 GND a_n3634_2342# a_n2911_2155# GND sky130_fd_pr__nfet_01v8 ad=0.126 pd=1.44 as=0.105 ps=0.92 w=0.42 l=0.15
X47 VDD a0 a_n1730_62# VDD sky130_fd_pr__pfet_01v8 ad=0.252 pd=2.28 as=0.21 ps=1.34 w=0.84 l=0.15
X48 a_n3317_141# b0 a_n3447_141# VDD sky130_fd_pr__pfet_01v8 ad=0.105 pd=0.92 as=0.105 ps=0.92 w=0.42 l=0.15
X49 a_n2911_3724# a_n3634_4699# sout5 GND sky130_fd_pr__nfet_01v8 ad=0.105 pd=0.92 as=0.126 ps=1.44 w=0.42 l=0.15
X50 a_n3634_765# b0 a_n1749_n266# GND sky130_fd_pr__nfet_01v8 ad=0.105 pd=0.92 as=0.126 ps=1.44 w=0.42 l=0.15
X51 VDD b0 a_n1008_62# VDD sky130_fd_pr__pfet_01v8 ad=0.21 pd=1.34 as=0.252 ps=2.28 w=0.84 l=0.15
X52 a_n3447_577# a_n3634_765# sout1 GND sky130_fd_pr__nfet_01v8 ad=0.105 pd=0.92 as=0.126 ps=1.44 w=0.42 l=0.15
X53 a_n1730_5538# b7 cout7 VDD sky130_fd_pr__pfet_01v8 ad=0.252 pd=2.28 as=0.21 ps=1.34 w=0.84 l=0.15
X54 a_n1749_2099# b3 a_n3634_3096# GND sky130_fd_pr__nfet_01v8 ad=0.126 pd=1.44 as=0.105 ps=0.92 w=0.42 l=0.15
X55 VDD a6 a_n2911_4863# VDD sky130_fd_pr__pfet_01v8 ad=0.105 pd=0.92 as=0.105 ps=0.92 w=0.42 l=0.15
X56 a_n1027_522# b1 GND GND sky130_fd_pr__nfet_01v8 ad=0.105 pd=0.92 as=0.105 ps=0.92 w=0.42 l=0.15
X57 VDD a_n3634_5453# a_n2911_5617# VDD sky130_fd_pr__pfet_01v8 ad=0.126 pd=1.44 as=0.105 ps=0.92 w=0.42 l=0.15
X58 VDD a6 a_n1730_4784# VDD sky130_fd_pr__pfet_01v8 ad=0.252 pd=2.28 as=0.21 ps=1.34 w=0.84 l=0.15
X59 a_n1008_3996# b5 VDD VDD sky130_fd_pr__pfet_01v8 ad=0.21 pd=1.34 as=0.21 ps=1.34 w=0.84 l=0.15
X60 a_n1749_5210# a7 GND GND sky130_fd_pr__nfet_01v8 ad=0.105 pd=0.92 as=0.126 ps=1.44 w=0.42 l=0.15
X61 GND b0 a_n1027_n266# GND sky130_fd_pr__nfet_01v8 ad=0.105 pd=0.92 as=0.126 ps=1.44 w=0.42 l=0.15
X62 a_n3447_5617# a_n3634_5453# sout7 VDD sky130_fd_pr__pfet_01v8 ad=0.105 pd=0.92 as=0.126 ps=1.44 w=0.42 l=0.15
X63 VDD a0 a_n3317_141# VDD sky130_fd_pr__pfet_01v8 ad=0.126 pd=1.44 as=0.105 ps=0.92 w=0.42 l=0.15
X64 a_n3634_2342# b2 a_n1730_1639# VDD sky130_fd_pr__pfet_01v8 ad=0.21 pd=1.34 as=0.252 ps=2.28 w=0.84 l=0.15
X65 GND a7 a_n2911_5266# GND sky130_fd_pr__nfet_01v8 ad=0.105 pd=0.92 as=0.105 ps=0.92 w=0.42 l=0.15
X66 a_n1027_2099# b3 GND GND sky130_fd_pr__nfet_01v8 ad=0.105 pd=0.92 as=0.105 ps=0.92 w=0.42 l=0.15
X67 a_n2911_n210# a_n3634_765# sout0 GND sky130_fd_pr__nfet_01v8 ad=0.105 pd=0.92 as=0.126 ps=1.44 w=0.42 l=0.15
X68 a_n3317_577# b1 a_n3447_577# GND sky130_fd_pr__nfet_01v8 ad=0.105 pd=0.92 as=0.105 ps=0.92 w=0.42 l=0.15
X69 a_n1027_1311# a_n3634_1554# a_n3634_2342# GND sky130_fd_pr__nfet_01v8 ad=0.126 pd=1.44 as=0.105 ps=0.92 w=0.42 l=0.15
X70 cout7 a_n3634_5453# a_n1008_5538# VDD sky130_fd_pr__pfet_01v8 ad=0.21 pd=1.34 as=0.252 ps=2.28 w=0.84 l=0.15
X71 a_n1749_3668# a5 GND GND sky130_fd_pr__nfet_01v8 ad=0.105 pd=0.92 as=0.126 ps=1.44 w=0.42 l=0.15
X72 a_n3634_3096# a_n3634_2342# a_n1027_2099# GND sky130_fd_pr__nfet_01v8 ad=0.105 pd=0.92 as=0.126 ps=1.44 w=0.42 l=0.15
X73 a_n2911_1718# b2 VDD VDD sky130_fd_pr__pfet_01v8 ad=0.105 pd=0.92 as=0.105 ps=0.92 w=0.42 l=0.15
X74 a_n3447_2908# a_n3634_3096# sout4 GND sky130_fd_pr__nfet_01v8 ad=0.105 pd=0.92 as=0.126 ps=1.44 w=0.42 l=0.15
X75 a_n1749_2853# a4 GND GND sky130_fd_pr__nfet_01v8 ad=0.105 pd=0.92 as=0.126 ps=1.44 w=0.42 l=0.15
X76 a_n2911_1367# a_n3634_2342# sout2 GND sky130_fd_pr__nfet_01v8 ad=0.105 pd=0.92 as=0.126 ps=1.44 w=0.42 l=0.15
X77 VDD b6 a_n1008_4784# VDD sky130_fd_pr__pfet_01v8 ad=0.21 pd=1.34 as=0.252 ps=2.28 w=0.84 l=0.15
X78 a_n1008_2427# b3 VDD VDD sky130_fd_pr__pfet_01v8 ad=0.21 pd=1.34 as=0.21 ps=1.34 w=0.84 l=0.15
X79 a_n2911_929# b1 VDD VDD sky130_fd_pr__pfet_01v8 ad=0.105 pd=0.92 as=0.105 ps=0.92 w=0.42 l=0.15
X80 VDD a7 a_n1008_5538# VDD sky130_fd_pr__pfet_01v8 ad=0.21 pd=1.34 as=0.21 ps=1.34 w=0.84 l=0.15
X81 a_n1027_4456# a_n3634_4699# a_n3634_5453# GND sky130_fd_pr__nfet_01v8 ad=0.126 pd=1.44 as=0.105 ps=0.92 w=0.42 l=0.15
X82 a_n1008_3181# b4 VDD VDD sky130_fd_pr__pfet_01v8 ad=0.21 pd=1.34 as=0.21 ps=1.34 w=0.84 l=0.15
X83 VDD a1 a_n1008_850# VDD sky130_fd_pr__pfet_01v8 ad=0.21 pd=1.34 as=0.21 ps=1.34 w=0.84 l=0.15
X84 a_n3634_1554# a_n3634_765# a_n1008_850# VDD sky130_fd_pr__pfet_01v8 ad=0.21 pd=1.34 as=0.252 ps=2.28 w=0.84 l=0.15
X85 GND a7 a_n1027_5210# GND sky130_fd_pr__nfet_01v8 ad=0.105 pd=0.92 as=0.105 ps=0.92 w=0.42 l=0.15
X86 GND a5 a_n2911_3724# GND sky130_fd_pr__nfet_01v8 ad=0.105 pd=0.92 as=0.105 ps=0.92 w=0.42 l=0.15
X87 GND a1 a_n3317_577# GND sky130_fd_pr__nfet_01v8 ad=0.126 pd=1.44 as=0.105 ps=0.92 w=0.42 l=0.15
X88 a_n1749_n266# b0 a_n3634_765# GND sky130_fd_pr__nfet_01v8 ad=0.126 pd=1.44 as=0.105 ps=0.92 w=0.42 l=0.15
X89 GND a5 a_n1027_3668# GND sky130_fd_pr__nfet_01v8 ad=0.105 pd=0.92 as=0.105 ps=0.92 w=0.42 l=0.15
X90 a_n3634_1554# a_n3634_765# a_n1027_522# GND sky130_fd_pr__nfet_01v8 ad=0.105 pd=0.92 as=0.126 ps=1.44 w=0.42 l=0.15
X91 VDD a_n3634_765# a_n2911_929# VDD sky130_fd_pr__pfet_01v8 ad=0.126 pd=1.44 as=0.105 ps=0.92 w=0.42 l=0.15
X92 GND a4 a_n1027_2853# GND sky130_fd_pr__nfet_01v8 ad=0.105 pd=0.92 as=0.105 ps=0.92 w=0.42 l=0.15
X93 a_n1008_850# a1 VDD VDD sky130_fd_pr__pfet_01v8 ad=0.252 pd=2.28 as=0.21 ps=1.34 w=0.84 l=0.15
X94 a_n1008_850# a_n3634_765# a_n3634_1554# VDD sky130_fd_pr__pfet_01v8 ad=0.252 pd=2.28 as=0.21 ps=1.34 w=0.84 l=0.15
X95 GND a7 a_n1749_5210# GND sky130_fd_pr__nfet_01v8 ad=0.126 pd=1.44 as=0.105 ps=0.92 w=0.42 l=0.15
X96 a_n1027_n266# b0 GND GND sky130_fd_pr__nfet_01v8 ad=0.105 pd=0.92 as=0.105 ps=0.92 w=0.42 l=0.15
X97 a_n3317_5617# b7 a_n3447_5617# VDD sky130_fd_pr__pfet_01v8 ad=0.105 pd=0.92 as=0.105 ps=0.92 w=0.42 l=0.15
X98 a_n3634_4699# b5 a_n1730_3996# VDD sky130_fd_pr__pfet_01v8 ad=0.21 pd=1.34 as=0.252 ps=2.28 w=0.84 l=0.15
X99 a_n3634_765# cin0 a_n1027_n266# GND sky130_fd_pr__nfet_01v8 ad=0.105 pd=0.92 as=0.126 ps=1.44 w=0.42 l=0.15
X100 a_n1730_1639# b2 a_n3634_2342# VDD sky130_fd_pr__pfet_01v8 ad=0.252 pd=2.28 as=0.21 ps=1.34 w=0.84 l=0.15
X101 a_n2911_4512# a_n3634_5453# sout6 GND sky130_fd_pr__nfet_01v8 ad=0.105 pd=0.92 as=0.126 ps=1.44 w=0.42 l=0.15
X102 GND a0 a_n2911_n210# GND sky130_fd_pr__nfet_01v8 ad=0.105 pd=0.92 as=0.105 ps=0.92 w=0.42 l=0.15
X103 a_n1008_62# a0 VDD VDD sky130_fd_pr__pfet_01v8 ad=0.252 pd=2.28 as=0.21 ps=1.34 w=0.84 l=0.15
X104 a_n1008_5538# a_n3634_5453# cout7 VDD sky130_fd_pr__pfet_01v8 ad=0.252 pd=2.28 as=0.21 ps=1.34 w=0.84 l=0.15
X105 GND a5 a_n1749_3668# GND sky130_fd_pr__nfet_01v8 ad=0.126 pd=1.44 as=0.105 ps=0.92 w=0.42 l=0.15
X106 a_n1027_2099# a_n3634_2342# a_n3634_3096# GND sky130_fd_pr__nfet_01v8 ad=0.126 pd=1.44 as=0.105 ps=0.92 w=0.42 l=0.15
X107 a_n1730_62# b0 a_n3634_765# VDD sky130_fd_pr__pfet_01v8 ad=0.252 pd=2.28 as=0.21 ps=1.34 w=0.84 l=0.15
X108 a_n1027_522# a_n3634_765# a_n3634_1554# GND sky130_fd_pr__nfet_01v8 ad=0.126 pd=1.44 as=0.105 ps=0.92 w=0.42 l=0.15
X109 VDD a_n3634_1554# a_n2911_1718# VDD sky130_fd_pr__pfet_01v8 ad=0.126 pd=1.44 as=0.105 ps=0.92 w=0.42 l=0.15
X110 a_n3317_2908# b4 a_n3447_2908# GND sky130_fd_pr__nfet_01v8 ad=0.105 pd=0.92 as=0.105 ps=0.92 w=0.42 l=0.15
X111 a_n1749_1311# a2 GND GND sky130_fd_pr__nfet_01v8 ad=0.105 pd=0.92 as=0.126 ps=1.44 w=0.42 l=0.15
X112 a_n3447_1718# a_n3634_1554# sout2 VDD sky130_fd_pr__pfet_01v8 ad=0.105 pd=0.92 as=0.126 ps=1.44 w=0.42 l=0.15
X113 a_n2911_929# a_n3634_1554# sout1 VDD sky130_fd_pr__pfet_01v8 ad=0.105 pd=0.92 as=0.126 ps=1.44 w=0.42 l=0.15
X114 GND a4 a_n1749_2853# GND sky130_fd_pr__nfet_01v8 ad=0.126 pd=1.44 as=0.105 ps=0.92 w=0.42 l=0.15
X115 GND a2 a_n2911_1367# GND sky130_fd_pr__nfet_01v8 ad=0.105 pd=0.92 as=0.105 ps=0.92 w=0.42 l=0.15
X116 a_n1008_4784# b6 VDD VDD sky130_fd_pr__pfet_01v8 ad=0.21 pd=1.34 as=0.21 ps=1.34 w=0.84 l=0.15
X117 a_n2911_141# b0 VDD VDD sky130_fd_pr__pfet_01v8 ad=0.105 pd=0.92 as=0.105 ps=0.92 w=0.42 l=0.15
X118 VDD b1 a_n1008_850# VDD sky130_fd_pr__pfet_01v8 ad=0.21 pd=1.34 as=0.252 ps=2.28 w=0.84 l=0.15
X119 a_n3634_2342# a_n3634_1554# a_n1008_1639# VDD sky130_fd_pr__pfet_01v8 ad=0.21 pd=1.34 as=0.252 ps=2.28 w=0.84 l=0.15
X120 a_n1008_5538# a7 VDD VDD sky130_fd_pr__pfet_01v8 ad=0.252 pd=2.28 as=0.21 ps=1.34 w=0.84 l=0.15
X121 a_n1730_62# a0 VDD VDD sky130_fd_pr__pfet_01v8 ad=0.21 pd=1.34 as=0.252 ps=2.28 w=0.84 l=0.15
X122 a_n2911_2909# b4 GND GND sky130_fd_pr__nfet_01v8 ad=0.105 pd=0.92 as=0.105 ps=0.92 w=0.42 l=0.15
X123 a_n1027_5210# a7 GND GND sky130_fd_pr__nfet_01v8 ad=0.126 pd=1.44 as=0.105 ps=0.92 w=0.42 l=0.15
X124 a_n2911_4075# b5 VDD VDD sky130_fd_pr__pfet_01v8 ad=0.105 pd=0.92 as=0.105 ps=0.92 w=0.42 l=0.15
X125 a_n3634_3096# b3 a_n1730_2427# VDD sky130_fd_pr__pfet_01v8 ad=0.21 pd=1.34 as=0.252 ps=2.28 w=0.84 l=0.15
X126 a_n3447_5265# a_n3634_5453# sout7 GND sky130_fd_pr__nfet_01v8 ad=0.105 pd=0.92 as=0.126 ps=1.44 w=0.42 l=0.15
X127 a_n1749_4456# a6 GND GND sky130_fd_pr__nfet_01v8 ad=0.105 pd=0.92 as=0.126 ps=1.44 w=0.42 l=0.15
X128 a_n3634_3911# b4 a_n1730_3181# VDD sky130_fd_pr__pfet_01v8 ad=0.21 pd=1.34 as=0.252 ps=2.28 w=0.84 l=0.15
X129 a_n2911_2506# b3 VDD VDD sky130_fd_pr__pfet_01v8 ad=0.105 pd=0.92 as=0.105 ps=0.92 w=0.42 l=0.15
X130 VDD a2 a_n1008_1639# VDD sky130_fd_pr__pfet_01v8 ad=0.21 pd=1.34 as=0.21 ps=1.34 w=0.84 l=0.15
X131 a_n1027_3668# a5 GND GND sky130_fd_pr__nfet_01v8 ad=0.126 pd=1.44 as=0.105 ps=0.92 w=0.42 l=0.15
X132 a_n2911_3260# b4 VDD VDD sky130_fd_pr__pfet_01v8 ad=0.105 pd=0.92 as=0.105 ps=0.92 w=0.42 l=0.15
X133 VDD a1 a_n2911_929# VDD sky130_fd_pr__pfet_01v8 ad=0.105 pd=0.92 as=0.105 ps=0.92 w=0.42 l=0.15
X134 a_n2911_2155# a_n3634_3096# sout3 GND sky130_fd_pr__nfet_01v8 ad=0.105 pd=0.92 as=0.126 ps=1.44 w=0.42 l=0.15
X135 VDD cin0 a_n2911_141# VDD sky130_fd_pr__pfet_01v8 ad=0.126 pd=1.44 as=0.105 ps=0.92 w=0.42 l=0.15
X136 GND a2 a_n1027_1311# GND sky130_fd_pr__nfet_01v8 ad=0.105 pd=0.92 as=0.105 ps=0.92 w=0.42 l=0.15
X137 a_n1027_2853# a4 GND GND sky130_fd_pr__nfet_01v8 ad=0.126 pd=1.44 as=0.105 ps=0.92 w=0.42 l=0.15
X138 a_n1008_850# b1 VDD VDD sky130_fd_pr__pfet_01v8 ad=0.21 pd=1.34 as=0.21 ps=1.34 w=0.84 l=0.15
X139 VDD a7 a_n3317_5617# VDD sky130_fd_pr__pfet_01v8 ad=0.126 pd=1.44 as=0.105 ps=0.92 w=0.42 l=0.15
X140 a_n1730_3996# b5 a_n3634_4699# VDD sky130_fd_pr__pfet_01v8 ad=0.252 pd=2.28 as=0.21 ps=1.34 w=0.84 l=0.15
X141 a_n1027_n266# cin0 a_n3634_765# GND sky130_fd_pr__nfet_01v8 ad=0.126 pd=1.44 as=0.105 ps=0.92 w=0.42 l=0.15
X142 GND a6 a_n2911_4512# GND sky130_fd_pr__nfet_01v8 ad=0.105 pd=0.92 as=0.105 ps=0.92 w=0.42 l=0.15
X143 a_n3447_3723# a_n3634_3911# sout5 GND sky130_fd_pr__nfet_01v8 ad=0.105 pd=0.92 as=0.126 ps=1.44 w=0.42 l=0.15
X144 GND a6 a_n1027_4456# GND sky130_fd_pr__nfet_01v8 ad=0.105 pd=0.92 as=0.105 ps=0.92 w=0.42 l=0.15
X145 GND a4 a_n3317_2908# GND sky130_fd_pr__nfet_01v8 ad=0.126 pd=1.44 as=0.105 ps=0.92 w=0.42 l=0.15
X146 GND a2 a_n1749_1311# GND sky130_fd_pr__nfet_01v8 ad=0.126 pd=1.44 as=0.105 ps=0.92 w=0.42 l=0.15
X147 a_n2911_5617# cout7 sout7 VDD sky130_fd_pr__pfet_01v8 ad=0.105 pd=0.92 as=0.126 ps=1.44 w=0.42 l=0.15
X148 a_n3317_1718# b2 a_n3447_1718# VDD sky130_fd_pr__pfet_01v8 ad=0.105 pd=0.92 as=0.105 ps=0.92 w=0.42 l=0.15
X149 a_n2911_141# a_n3634_765# sout0 VDD sky130_fd_pr__pfet_01v8 ad=0.105 pd=0.92 as=0.126 ps=1.44 w=0.42 l=0.15
X150 a_n1730_5538# a7 VDD VDD sky130_fd_pr__pfet_01v8 ad=0.21 pd=1.34 as=0.252 ps=2.28 w=0.84 l=0.15
X151 a_n1749_2099# a3 GND GND sky130_fd_pr__nfet_01v8 ad=0.105 pd=0.92 as=0.126 ps=1.44 w=0.42 l=0.15
X152 a_n1008_1639# a_n3634_1554# a_n3634_2342# VDD sky130_fd_pr__pfet_01v8 ad=0.252 pd=2.28 as=0.21 ps=1.34 w=0.84 l=0.15
X153 a_n3634_4699# a_n3634_3911# a_n1008_3996# VDD sky130_fd_pr__pfet_01v8 ad=0.21 pd=1.34 as=0.252 ps=2.28 w=0.84 l=0.15
X154 a_n3447_n211# cin0 sout0 GND sky130_fd_pr__nfet_01v8 ad=0.105 pd=0.92 as=0.126 ps=1.44 w=0.42 l=0.15
X155 GND a_n3634_3096# a_n2911_2909# GND sky130_fd_pr__nfet_01v8 ad=0.126 pd=1.44 as=0.105 ps=0.92 w=0.42 l=0.15
X156 a_n3634_5453# b6 a_n1730_4784# VDD sky130_fd_pr__pfet_01v8 ad=0.21 pd=1.34 as=0.252 ps=2.28 w=0.84 l=0.15
X157 VDD a_n3634_3911# a_n2911_4075# VDD sky130_fd_pr__pfet_01v8 ad=0.126 pd=1.44 as=0.105 ps=0.92 w=0.42 l=0.15
X158 a_n1730_2427# b3 a_n3634_3096# VDD sky130_fd_pr__pfet_01v8 ad=0.252 pd=2.28 as=0.21 ps=1.34 w=0.84 l=0.15
X159 a_n3317_5265# b7 a_n3447_5265# GND sky130_fd_pr__nfet_01v8 ad=0.105 pd=0.92 as=0.105 ps=0.92 w=0.42 l=0.15
X160 GND a6 a_n1749_4456# GND sky130_fd_pr__nfet_01v8 ad=0.126 pd=1.44 as=0.105 ps=0.92 w=0.42 l=0.15
X161 a_n1730_3181# b4 a_n3634_3911# VDD sky130_fd_pr__pfet_01v8 ad=0.252 pd=2.28 as=0.21 ps=1.34 w=0.84 l=0.15
X162 a_n2911_4863# b6 VDD VDD sky130_fd_pr__pfet_01v8 ad=0.105 pd=0.92 as=0.105 ps=0.92 w=0.42 l=0.15
X163 a_n3447_4075# a_n3634_3911# sout5 VDD sky130_fd_pr__pfet_01v8 ad=0.105 pd=0.92 as=0.126 ps=1.44 w=0.42 l=0.15
X164 VDD a_n3634_2342# a_n2911_2506# VDD sky130_fd_pr__pfet_01v8 ad=0.126 pd=1.44 as=0.105 ps=0.92 w=0.42 l=0.15
X165 a_n1008_1639# a2 VDD VDD sky130_fd_pr__pfet_01v8 ad=0.252 pd=2.28 as=0.21 ps=1.34 w=0.84 l=0.15
X166 VDD a5 a_n1008_3996# VDD sky130_fd_pr__pfet_01v8 ad=0.21 pd=1.34 as=0.21 ps=1.34 w=0.84 l=0.15
X167 VDD a_n3634_3096# a_n2911_3260# VDD sky130_fd_pr__pfet_01v8 ad=0.126 pd=1.44 as=0.105 ps=0.92 w=0.42 l=0.15
X168 VDD a0 a_n2911_141# VDD sky130_fd_pr__pfet_01v8 ad=0.105 pd=0.92 as=0.105 ps=0.92 w=0.42 l=0.15
X169 a_n3447_2506# a_n3634_2342# sout3 VDD sky130_fd_pr__pfet_01v8 ad=0.105 pd=0.92 as=0.126 ps=1.44 w=0.42 l=0.15
X170 GND a3 a_n2911_2155# GND sky130_fd_pr__nfet_01v8 ad=0.105 pd=0.92 as=0.105 ps=0.92 w=0.42 l=0.15
X171 a_n1027_1311# a2 GND GND sky130_fd_pr__nfet_01v8 ad=0.126 pd=1.44 as=0.105 ps=0.92 w=0.42 l=0.15
X172 a_n3447_1366# a_n3634_1554# sout2 GND sky130_fd_pr__nfet_01v8 ad=0.105 pd=0.92 as=0.126 ps=1.44 w=0.42 l=0.15
X173 a_n2911_5266# b7 GND GND sky130_fd_pr__nfet_01v8 ad=0.105 pd=0.92 as=0.105 ps=0.92 w=0.42 l=0.15
X174 a_n3447_3260# a_n3634_3096# sout4 VDD sky130_fd_pr__pfet_01v8 ad=0.105 pd=0.92 as=0.126 ps=1.44 w=0.42 l=0.15
X175 a_n3634_3096# a_n3634_2342# a_n1008_2427# VDD sky130_fd_pr__pfet_01v8 ad=0.21 pd=1.34 as=0.252 ps=2.28 w=0.84 l=0.15
X176 GND a3 a_n1027_2099# GND sky130_fd_pr__nfet_01v8 ad=0.105 pd=0.92 as=0.105 ps=0.92 w=0.42 l=0.15
X177 a_n3634_3911# a_n3634_3096# a_n1008_3181# VDD sky130_fd_pr__pfet_01v8 ad=0.21 pd=1.34 as=0.252 ps=2.28 w=0.84 l=0.15
X178 a_n3317_3723# b5 a_n3447_3723# GND sky130_fd_pr__nfet_01v8 ad=0.105 pd=0.92 as=0.105 ps=0.92 w=0.42 l=0.15
X179 VDD a0 a_n1008_62# VDD sky130_fd_pr__pfet_01v8 ad=0.21 pd=1.34 as=0.21 ps=1.34 w=0.84 l=0.15
X180 a_n1008_62# cin0 a_n3634_765# VDD sky130_fd_pr__pfet_01v8 ad=0.252 pd=2.28 as=0.21 ps=1.34 w=0.84 l=0.15
X181 VDD a3 a_n1008_2427# VDD sky130_fd_pr__pfet_01v8 ad=0.21 pd=1.34 as=0.21 ps=1.34 w=0.84 l=0.15
X182 a_n3634_765# b0 a_n1730_62# VDD sky130_fd_pr__pfet_01v8 ad=0.21 pd=1.34 as=0.252 ps=2.28 w=0.84 l=0.15
X183 a_n1027_4456# a6 GND GND sky130_fd_pr__nfet_01v8 ad=0.126 pd=1.44 as=0.105 ps=0.92 w=0.42 l=0.15
X184 a_n1749_n266# a0 GND GND sky130_fd_pr__nfet_01v8 ad=0.105 pd=0.92 as=0.126 ps=1.44 w=0.42 l=0.15
X185 VDD a7 a_n2911_5617# VDD sky130_fd_pr__pfet_01v8 ad=0.105 pd=0.92 as=0.105 ps=0.92 w=0.42 l=0.15
X186 VDD a4 a_n1008_3181# VDD sky130_fd_pr__pfet_01v8 ad=0.21 pd=1.34 as=0.21 ps=1.34 w=0.84 l=0.15
X187 VDD a2 a_n3317_1718# VDD sky130_fd_pr__pfet_01v8 ad=0.126 pd=1.44 as=0.105 ps=0.92 w=0.42 l=0.15
X188 VDD a7 a_n1730_5538# VDD sky130_fd_pr__pfet_01v8 ad=0.252 pd=2.28 as=0.21 ps=1.34 w=0.84 l=0.15
X189 GND a3 a_n1749_2099# GND sky130_fd_pr__nfet_01v8 ad=0.126 pd=1.44 as=0.105 ps=0.92 w=0.42 l=0.15
X190 a_n1008_3996# a_n3634_3911# a_n3634_4699# VDD sky130_fd_pr__pfet_01v8 ad=0.252 pd=2.28 as=0.21 ps=1.34 w=0.84 l=0.15
X191 a_n2911_3724# b5 GND GND sky130_fd_pr__nfet_01v8 ad=0.105 pd=0.92 as=0.105 ps=0.92 w=0.42 l=0.15
X192 a_n3317_n211# b0 a_n3447_n211# GND sky130_fd_pr__nfet_01v8 ad=0.105 pd=0.92 as=0.105 ps=0.92 w=0.42 l=0.15
X193 a_n2911_1718# a_n3634_2342# sout2 VDD sky130_fd_pr__pfet_01v8 ad=0.105 pd=0.92 as=0.126 ps=1.44 w=0.42 l=0.15
X194 a_n1730_4784# b6 a_n3634_5453# VDD sky130_fd_pr__pfet_01v8 ad=0.252 pd=2.28 as=0.21 ps=1.34 w=0.84 l=0.15
X195 a_n1730_1639# a2 VDD VDD sky130_fd_pr__pfet_01v8 ad=0.21 pd=1.34 as=0.252 ps=2.28 w=0.84 l=0.15
X196 GND a7 a_n3317_5265# GND sky130_fd_pr__nfet_01v8 ad=0.126 pd=1.44 as=0.105 ps=0.92 w=0.42 l=0.15
X197 cout7 b7 a_n1749_5210# GND sky130_fd_pr__nfet_01v8 ad=0.105 pd=0.92 as=0.126 ps=1.44 w=0.42 l=0.15
X198 a_n3447_4511# a_n3634_4699# sout6 GND sky130_fd_pr__nfet_01v8 ad=0.105 pd=0.92 as=0.126 ps=1.44 w=0.42 l=0.15
X199 VDD a_n3634_4699# a_n2911_4863# VDD sky130_fd_pr__pfet_01v8 ad=0.126 pd=1.44 as=0.105 ps=0.92 w=0.42 l=0.15
X200 a_n3317_4075# b5 a_n3447_4075# VDD sky130_fd_pr__pfet_01v8 ad=0.105 pd=0.92 as=0.105 ps=0.92 w=0.42 l=0.15
X201 a_n1008_3996# a5 VDD VDD sky130_fd_pr__pfet_01v8 ad=0.252 pd=2.28 as=0.21 ps=1.34 w=0.84 l=0.15
X202 VDD b7 a_n1008_5538# VDD sky130_fd_pr__pfet_01v8 ad=0.21 pd=1.34 as=0.252 ps=2.28 w=0.84 l=0.15
X203 a_n3447_4863# a_n3634_4699# sout6 VDD sky130_fd_pr__pfet_01v8 ad=0.105 pd=0.92 as=0.126 ps=1.44 w=0.42 l=0.15
X204 a_n3634_4699# b5 a_n1749_3668# GND sky130_fd_pr__nfet_01v8 ad=0.105 pd=0.92 as=0.126 ps=1.44 w=0.42 l=0.15
X205 a_n3317_2506# b3 a_n3447_2506# VDD sky130_fd_pr__pfet_01v8 ad=0.105 pd=0.92 as=0.105 ps=0.92 w=0.42 l=0.15
X206 GND a0 a_n1027_n266# GND sky130_fd_pr__nfet_01v8 ad=0.105 pd=0.92 as=0.105 ps=0.92 w=0.42 l=0.15
X207 a_n3317_1366# b2 a_n3447_1366# GND sky130_fd_pr__nfet_01v8 ad=0.105 pd=0.92 as=0.105 ps=0.92 w=0.42 l=0.15
X208 GND a_n3634_5453# a_n2911_5266# GND sky130_fd_pr__nfet_01v8 ad=0.126 pd=1.44 as=0.105 ps=0.92 w=0.42 l=0.15
X209 GND b7 a_n1027_5210# GND sky130_fd_pr__nfet_01v8 ad=0.105 pd=0.92 as=0.126 ps=1.44 w=0.42 l=0.15
X210 a_n3634_5453# a_n3634_4699# a_n1008_4784# VDD sky130_fd_pr__pfet_01v8 ad=0.21 pd=1.34 as=0.252 ps=2.28 w=0.84 l=0.15
X211 a_n3317_3260# b4 a_n3447_3260# VDD sky130_fd_pr__pfet_01v8 ad=0.105 pd=0.92 as=0.105 ps=0.92 w=0.42 l=0.15
X212 a_n1008_2427# a_n3634_2342# a_n3634_3096# VDD sky130_fd_pr__pfet_01v8 ad=0.252 pd=2.28 as=0.21 ps=1.34 w=0.84 l=0.15
X213 a_n1027_2099# a3 GND GND sky130_fd_pr__nfet_01v8 ad=0.126 pd=1.44 as=0.105 ps=0.92 w=0.42 l=0.15
X214 a_n2911_n210# b0 GND GND sky130_fd_pr__nfet_01v8 ad=0.105 pd=0.92 as=0.105 ps=0.92 w=0.42 l=0.15
X215 a_n3634_3911# b4 a_n1749_2853# GND sky130_fd_pr__nfet_01v8 ad=0.105 pd=0.92 as=0.126 ps=1.44 w=0.42 l=0.15
X216 a_n1008_3181# a_n3634_3096# a_n3634_3911# VDD sky130_fd_pr__pfet_01v8 ad=0.252 pd=2.28 as=0.21 ps=1.34 w=0.84 l=0.15
X217 GND b5 a_n1027_3668# GND sky130_fd_pr__nfet_01v8 ad=0.105 pd=0.92 as=0.126 ps=1.44 w=0.42 l=0.15
X218 GND a5 a_n3317_3723# GND sky130_fd_pr__nfet_01v8 ad=0.126 pd=1.44 as=0.105 ps=0.92 w=0.42 l=0.15
X219 a_n2911_1367# b2 GND GND sky130_fd_pr__nfet_01v8 ad=0.105 pd=0.92 as=0.105 ps=0.92 w=0.42 l=0.15
X220 a_n1008_2427# a3 VDD VDD sky130_fd_pr__pfet_01v8 ad=0.252 pd=2.28 as=0.21 ps=1.34 w=0.84 l=0.15
X221 VDD a6 a_n1008_4784# VDD sky130_fd_pr__pfet_01v8 ad=0.21 pd=1.34 as=0.21 ps=1.34 w=0.84 l=0.15
X222 GND b4 a_n1027_2853# GND sky130_fd_pr__nfet_01v8 ad=0.105 pd=0.92 as=0.126 ps=1.44 w=0.42 l=0.15
X223 GND a0 a_n1749_n266# GND sky130_fd_pr__nfet_01v8 ad=0.126 pd=1.44 as=0.105 ps=0.92 w=0.42 l=0.15
X224 a_n1008_3181# a4 VDD VDD sky130_fd_pr__pfet_01v8 ad=0.252 pd=2.28 as=0.21 ps=1.34 w=0.84 l=0.15
X225 a_n3447_2154# a_n3634_2342# sout3 GND sky130_fd_pr__nfet_01v8 ad=0.105 pd=0.92 as=0.126 ps=1.44 w=0.42 l=0.15
X226 a_n2911_578# b1 GND GND sky130_fd_pr__nfet_01v8 ad=0.105 pd=0.92 as=0.105 ps=0.92 w=0.42 l=0.15
X227 GND a_n3634_3911# a_n2911_3724# GND sky130_fd_pr__nfet_01v8 ad=0.126 pd=1.44 as=0.105 ps=0.92 w=0.42 l=0.15
X228 GND a0 a_n3317_n211# GND sky130_fd_pr__nfet_01v8 ad=0.126 pd=1.44 as=0.105 ps=0.92 w=0.42 l=0.15
X229 VDD a2 a_n2911_1718# VDD sky130_fd_pr__pfet_01v8 ad=0.105 pd=0.92 as=0.105 ps=0.92 w=0.42 l=0.15
X230 a_n1730_3996# a5 VDD VDD sky130_fd_pr__pfet_01v8 ad=0.21 pd=1.34 as=0.252 ps=2.28 w=0.84 l=0.15
X231 VDD a2 a_n1730_1639# VDD sky130_fd_pr__pfet_01v8 ad=0.252 pd=2.28 as=0.21 ps=1.34 w=0.84 l=0.15
X232 a_n1749_5210# b7 cout7 GND sky130_fd_pr__nfet_01v8 ad=0.126 pd=1.44 as=0.105 ps=0.92 w=0.42 l=0.15
X233 a_n3317_4511# b6 a_n3447_4511# GND sky130_fd_pr__nfet_01v8 ad=0.105 pd=0.92 as=0.105 ps=0.92 w=0.42 l=0.15
X234 VDD a5 a_n3317_4075# VDD sky130_fd_pr__pfet_01v8 ad=0.126 pd=1.44 as=0.105 ps=0.92 w=0.42 l=0.15
X235 a_n1008_5538# b7 VDD VDD sky130_fd_pr__pfet_01v8 ad=0.21 pd=1.34 as=0.21 ps=1.34 w=0.84 l=0.15
X236 a_n3317_4863# b6 a_n3447_4863# VDD sky130_fd_pr__pfet_01v8 ad=0.105 pd=0.92 as=0.105 ps=0.92 w=0.42 l=0.15
X237 a_n1749_3668# b5 a_n3634_4699# GND sky130_fd_pr__nfet_01v8 ad=0.126 pd=1.44 as=0.105 ps=0.92 w=0.42 l=0.15
X238 VDD a3 a_n3317_2506# VDD sky130_fd_pr__pfet_01v8 ad=0.126 pd=1.44 as=0.105 ps=0.92 w=0.42 l=0.15
X239 a_n1027_n266# a0 GND GND sky130_fd_pr__nfet_01v8 ad=0.126 pd=1.44 as=0.105 ps=0.92 w=0.42 l=0.15
X240 a_n1008_62# b0 VDD VDD sky130_fd_pr__pfet_01v8 ad=0.21 pd=1.34 as=0.21 ps=1.34 w=0.84 l=0.15
X241 GND a_n3634_765# a_n2911_578# GND sky130_fd_pr__nfet_01v8 ad=0.126 pd=1.44 as=0.105 ps=0.92 w=0.42 l=0.15
X242 a_n2911_2909# a_n3634_3911# sout4 GND sky130_fd_pr__nfet_01v8 ad=0.105 pd=0.92 as=0.126 ps=1.44 w=0.42 l=0.15
X243 a_n3634_2342# b2 a_n1749_1311# GND sky130_fd_pr__nfet_01v8 ad=0.105 pd=0.92 as=0.126 ps=1.44 w=0.42 l=0.15
X244 GND a2 a_n3317_1366# GND sky130_fd_pr__nfet_01v8 ad=0.126 pd=1.44 as=0.105 ps=0.92 w=0.42 l=0.15
X245 a_n1027_5210# b7 GND GND sky130_fd_pr__nfet_01v8 ad=0.105 pd=0.92 as=0.105 ps=0.92 w=0.42 l=0.15
X246 a_n1008_4784# a_n3634_4699# a_n3634_5453# VDD sky130_fd_pr__pfet_01v8 ad=0.252 pd=2.28 as=0.21 ps=1.34 w=0.84 l=0.15
X247 a_n2911_4512# b6 GND GND sky130_fd_pr__nfet_01v8 ad=0.105 pd=0.92 as=0.105 ps=0.92 w=0.42 l=0.15
X248 a_n2911_4075# a_n3634_4699# sout5 VDD sky130_fd_pr__pfet_01v8 ad=0.105 pd=0.92 as=0.126 ps=1.44 w=0.42 l=0.15
X249 VDD a4 a_n3317_3260# VDD sky130_fd_pr__pfet_01v8 ad=0.126 pd=1.44 as=0.105 ps=0.92 w=0.42 l=0.15
X250 GND cin0 a_n2911_n210# GND sky130_fd_pr__nfet_01v8 ad=0.126 pd=1.44 as=0.105 ps=0.92 w=0.42 l=0.15
X251 cout7 a_n3634_5453# a_n1027_5210# GND sky130_fd_pr__nfet_01v8 ad=0.105 pd=0.92 as=0.126 ps=1.44 w=0.42 l=0.15
X252 a_n1749_2853# b4 a_n3634_3911# GND sky130_fd_pr__nfet_01v8 ad=0.126 pd=1.44 as=0.105 ps=0.92 w=0.42 l=0.15
X253 a_n2911_2506# a_n3634_3096# sout3 VDD sky130_fd_pr__pfet_01v8 ad=0.105 pd=0.92 as=0.126 ps=1.44 w=0.42 l=0.15
X254 a_n1730_850# a1 VDD VDD sky130_fd_pr__pfet_01v8 ad=0.21 pd=1.34 as=0.252 ps=2.28 w=0.84 l=0.15
X255 VDD b2 a_n1008_1639# VDD sky130_fd_pr__pfet_01v8 ad=0.21 pd=1.34 as=0.252 ps=2.28 w=0.84 l=0.15
X256 a_n1027_3668# b5 GND GND sky130_fd_pr__nfet_01v8 ad=0.105 pd=0.92 as=0.105 ps=0.92 w=0.42 l=0.15
X257 a_n2911_3260# a_n3634_3911# sout4 VDD sky130_fd_pr__pfet_01v8 ad=0.105 pd=0.92 as=0.126 ps=1.44 w=0.42 l=0.15
X258 a_n1730_2427# a3 VDD VDD sky130_fd_pr__pfet_01v8 ad=0.21 pd=1.34 as=0.252 ps=2.28 w=0.84 l=0.15
X259 a_n3634_4699# a_n3634_3911# a_n1027_3668# GND sky130_fd_pr__nfet_01v8 ad=0.105 pd=0.92 as=0.126 ps=1.44 w=0.42 l=0.15
X260 a_n1730_3181# a4 VDD VDD sky130_fd_pr__pfet_01v8 ad=0.21 pd=1.34 as=0.252 ps=2.28 w=0.84 l=0.15
X261 a_n3634_765# cin0 a_n1008_62# VDD sky130_fd_pr__pfet_01v8 ad=0.21 pd=1.34 as=0.252 ps=2.28 w=0.84 l=0.15
X262 GND b2 a_n1027_1311# GND sky130_fd_pr__nfet_01v8 ad=0.105 pd=0.92 as=0.126 ps=1.44 w=0.42 l=0.15
X263 GND a_n3634_1554# a_n2911_1367# GND sky130_fd_pr__nfet_01v8 ad=0.126 pd=1.44 as=0.105 ps=0.92 w=0.42 l=0.15
X264 a_n1008_4784# a6 VDD VDD sky130_fd_pr__pfet_01v8 ad=0.252 pd=2.28 as=0.21 ps=1.34 w=0.84 l=0.15
X265 a_n3634_5453# b6 a_n1749_4456# GND sky130_fd_pr__nfet_01v8 ad=0.105 pd=0.92 as=0.126 ps=1.44 w=0.42 l=0.15
X266 a_n1027_2853# b4 GND GND sky130_fd_pr__nfet_01v8 ad=0.105 pd=0.92 as=0.105 ps=0.92 w=0.42 l=0.15
X267 a_n1749_522# a1 GND GND sky130_fd_pr__nfet_01v8 ad=0.105 pd=0.92 as=0.126 ps=1.44 w=0.42 l=0.15
X268 a_n2911_578# a_n3634_1554# sout1 GND sky130_fd_pr__nfet_01v8 ad=0.105 pd=0.92 as=0.126 ps=1.44 w=0.42 l=0.15
X269 a_n3447_929# a_n3634_765# sout1 VDD sky130_fd_pr__pfet_01v8 ad=0.105 pd=0.92 as=0.126 ps=1.44 w=0.42 l=0.15
X270 a_n3634_3911# a_n3634_3096# a_n1027_2853# GND sky130_fd_pr__nfet_01v8 ad=0.105 pd=0.92 as=0.126 ps=1.44 w=0.42 l=0.15
X271 a_n3317_2154# b3 a_n3447_2154# GND sky130_fd_pr__nfet_01v8 ad=0.105 pd=0.92 as=0.105 ps=0.92 w=0.42 l=0.15
C0 a_n1027_n266# b0 0.177862f
C1 sout4 a4 0.119864f
C2 sout2 a_n3447_1718# 0.036174f
C3 a_n3317_1366# a_n3317_929# 0.002266f
C4 a_n2911_1367# a_n1749_1311# 1.46e-19
C5 a_n1027_3668# a_n1008_3181# 0.014271f
C6 b2 a_n1730_850# 1.74e-19
C7 a_n3447_n211# a_n3634_765# 3.77e-20
C8 b1 sout2 2.05e-19
C9 a_n3447_1366# b2 0.010473f
C10 b3 a_n2911_2506# 0.073347f
C11 a_n3317_4863# a_n3634_5453# 8.28e-19
C12 a_n1027_2099# b4 1.93e-19
C13 a_n3447_2908# a_n3634_2342# 6.03e-19
C14 a_n1749_4456# a_n1749_5210# 6.57e-19
C15 sout5 a_n3447_3723# 0.031223f
C16 a2 a_n1749_1311# 0.065929f
C17 a_n1749_522# a_n1730_850# 0.00772f
C18 a_n3634_5453# b5 1.33e-19
C19 a_n1008_2427# a_n2911_2506# 4.52e-22
C20 a_n3634_4699# a7 0.010185f
C21 sout1 a_n3317_929# 0.018476f
C22 a6 a_n1730_3996# 4.38e-19
C23 a_n3317_1366# b2 0.002741f
C24 b3 a_n2911_2909# 7.03e-19
C25 b6 a_n1730_3996# 1.75e-19
C26 cin0 a1 0.006551f
C27 sout0 a_n3634_765# 0.087701f
C28 a_n3447_3260# b4 0.004422f
C29 a1 a_n3317_141# 1.04e-19
C30 a_n3634_765# a_n3447_141# 7.67e-19
C31 a5 a_n3634_4699# 0.638273f
C32 a_n1749_2099# sout3 8.56e-21
C33 a_n3317_2908# a_n3634_3096# 0.001568f
C34 a_n3447_1366# a_n3447_929# 0.002266f
C35 sout1 b2 0.001864f
C36 a_n3317_4863# VDD 0.029633f
C37 a_n1027_1311# a_n3634_765# 0.030706f
C38 a_n3447_5265# cout7 3.77e-20
C39 a_n3634_5453# a_n3447_4511# 3.77e-20
C40 a_n3634_3096# a_n3447_2506# 8.28e-19
C41 b4 a_n3634_2342# 0.003529f
C42 a_n3317_4511# a_n3634_4699# 0.001568f
C43 a_n3317_5265# cout7 4.61e-20
C44 a_n1730_1639# a_n3634_2342# 0.125919f
C45 VDD b5 1.01764f
C46 a_n1027_n266# a_n3634_765# 0.100537f
C47 b2 a_n2911_1718# 0.073347f
C48 a_n1749_522# sout1 8.56e-21
C49 a_n2911_4075# b5 0.073347f
C50 a_n2911_4863# a6 0.074154f
C51 a_n1749_522# a_n2911_578# 1.46e-19
C52 a_n1027_2853# a_n1749_2853# 0.019488f
C53 a_n2911_4863# b6 0.073347f
C54 a_n3634_3096# sout3 0.088013f
C55 a5 a4 0.035972f
C56 VDD a_n1027_2853# 0.033385f
C57 sout1 a0 5.56e-19
C58 sout5 a_n1730_3996# 7.26e-20
C59 a_n2911_578# a0 7.59e-19
C60 a_n1749_3668# a5 0.065929f
C61 sout4 a_n1730_3181# 7.26e-20
C62 a_n1027_522# a2 1.76e-19
C63 b1 a_n3447_577# 0.010473f
C64 a3 a_n1027_2853# 0.003484f
C65 sout2 a_n3634_1554# 0.111002f
C66 b5 a_n1008_3996# 0.201653f
C67 a1 a_n1730_850# 0.033659f
C68 a_n3447_1718# a_n3634_1554# 0.003618f
C69 a_n3634_3096# a_n3634_3911# 0.546216f
C70 a_n3317_5617# sout7 0.018476f
C71 b1 a_n3634_1554# 0.904028f
C72 a_n3634_5453# sout7 0.111015f
C73 a_n3447_2154# a_n3634_3096# 3.77e-20
C74 a_n3317_n211# a0 0.001953f
C75 a_n1027_3668# a_n3634_4699# 0.100409f
C76 a_n3447_2908# VDD 0.00106f
C77 a_n3634_765# b0 0.904909f
C78 sout0 a_n1730_62# 7.26e-20
C79 a_n2911_2155# sout3 0.041347f
C80 a_n3317_3260# a4 0.001237f
C81 sout1 a_n3447_929# 0.036174f
C82 a_n3447_4511# VDD 9.21e-19
C83 b3 a2 3.06e-20
C84 a_n2911_5617# sout7 0.034167f
C85 a_n1749_4456# a6 0.065929f
C86 a_n1749_4456# b6 0.036154f
C87 a_n2911_929# a_n3634_765# 0.019818f
C88 a_n1027_522# a_n1008_850# 0.009429f
C89 a_n3447_5265# b7 0.010473f
C90 a_n3317_3723# VDD 9.23e-19
C91 a_n3447_5617# b7 0.004422f
C92 a_n3447_3723# a_n3634_3911# 0.002776f
C93 a_n1027_3668# a4 0.002992f
C94 a_n1749_3668# a_n1027_3668# 0.019488f
C95 a_n3317_4075# b5 0.004341f
C96 a_n3317_5265# b7 0.002741f
C97 a_n1027_1311# a_n1749_1311# 0.019488f
C98 sout1 a1 0.119864f
C99 a1 a_n2911_578# 0.045558f
C100 a_n3447_1366# a_n3634_2342# 3.77e-20
C101 sout7 VDD 0.155231f
C102 b4 a_n1749_2853# 0.036154f
C103 sout2 a_n3317_929# 2.04e-19
C104 b4 VDD 1.02195f
C105 a_n2911_5266# a7 0.045558f
C106 a_n1730_1639# VDD 0.361997f
C107 a_n2911_4863# cout7 1.57e-20
C108 b4 a3 3.42e-20
C109 a_n1008_62# a0 0.169292f
C110 a_n3634_5453# a_n3447_4863# 8.28e-19
C111 b1 a_n3317_929# 0.004341f
C112 a_n1730_1639# a3 4.38e-19
C113 a_n1730_62# b0 0.26536f
C114 a_n3317_1366# a_n3634_2342# 4.61e-20
C115 a_n3634_1554# a_n3447_577# 3.77e-20
C116 a_n1027_5210# a_n3634_4699# 0.046544f
C117 a5 a_n1730_3181# 3.97e-19
C118 cin0 VDD 0.954111f
C119 sout2 b2 0.16871f
C120 a_n1749_522# a_n1749_n266# 6.28e-19
C121 a_n1027_2099# a4 1.95e-19
C122 a_n1749_4456# a_n2911_4512# 1.46e-19
C123 VDD a_n3317_141# 0.029633f
C124 a_n3447_1718# b2 0.004422f
C125 sout3 a_n1730_2427# 7.26e-20
C126 a_n1749_5210# sout7 8.56e-21
C127 a_n2911_2909# a_n1027_2853# 7.89e-21
C128 a_n1749_n266# a0 0.065929f
C129 a_n1749_4456# a_n1027_4456# 0.019488f
C130 VDD a_n1008_3181# 0.627796f
C131 b1 b2 0.021122f
C132 sout1 a_n3634_2342# 0.003066f
C133 a_n1730_3996# a_n3634_3911# 0.056654f
C134 a_n3447_5265# sout6 5.62e-19
C135 a_n3317_4863# a6 0.001237f
C136 a_n3317_4863# b6 0.004341f
C137 a_n1730_1639# a_n1008_1639# 0.032245f
C138 b3 a_n3447_2506# 0.004422f
C139 VDD a_n3447_4863# 0.01215f
C140 a_n1027_522# a_n1027_1311# 0.004706f
C141 b1 a_n1749_522# 0.036154f
C142 a_n3634_2342# a_n2911_1718# 0.007995f
C143 a_n3317_5265# sout6 5.62e-19
C144 a_n1008_3181# a_n1008_3996# 3e-19
C145 a6 b5 8.04e-19
C146 b6 b5 0.021185f
C147 b1 a0 3.06e-20
C148 a_n1008_62# a1 2.72e-19
C149 a_n1749_2099# a_n3634_3096# 0.150082f
C150 a_n2911_3724# a5 0.045558f
C151 b3 sout3 0.16871f
C152 a_n3317_2908# a_n3317_2506# 0.002491f
C153 a_n2911_4863# b7 5.06e-19
C154 a_n1027_522# a_n1027_n266# 0.004712f
C155 VDD a_n1730_850# 0.361997f
C156 sout2 a_n3447_929# 1.44e-19
C157 a_n3447_1366# VDD 9.18e-19
C158 a_n3447_2506# a_n3317_2506# 0.014951f
C159 b4 a_n2911_2506# 5.06e-19
C160 b3 a_n3634_3911# 1.53e-19
C161 a_n3634_2342# a4 0.010185f
C162 b3 a_n1027_1311# 1.74e-19
C163 a_n1749_2099# a_n2911_2155# 1.46e-19
C164 b1 a_n3447_929# 0.004422f
C165 a_n2911_3260# b5 4.03e-19
C166 a_n3447_2154# b3 0.010473f
C167 a_n3317_929# a_n3634_1554# 7.65e-19
C168 a_n3634_5453# a_n3634_4699# 0.568869f
C169 a_n3634_765# a_n1730_62# 0.125919f
C170 a1 a_n1749_n266# 9.55e-20
C171 sout4 a5 0.004392f
C172 sout3 a_n3317_2506# 0.018476f
C173 a_n1027_522# b0 0.008248f
C174 sout7 a_n1730_5538# 7.26e-20
C175 b6 a_n3447_4511# 0.010473f
C176 a_n1730_4784# a_n3634_4699# 0.056654f
C177 a_n3317_1366# VDD 0.00101f
C178 cin0 a_n2911_141# 0.019818f
C179 b4 a_n2911_2909# 0.007386f
C180 a_n3634_765# a_n1749_1311# 0.077605f
C181 sout5 b5 0.16871f
C182 sout2 a1 5.55e-19
C183 a_n1749_2099# a_n1749_1311# 6.28e-19
C184 a_n3634_3096# a_n2911_2155# 0.132214f
C185 sout4 a_n3317_3260# 0.018476f
C186 a_n2911_3724# a_n1027_3668# 7.89e-21
C187 a_n3634_1554# b2 0.614483f
C188 b1 a1 1.02288f
C189 a_n2911_4512# b5 6.54e-19
C190 sout1 VDD 0.154717f
C191 VDD a_n2911_578# 0.003014f
C192 a_n1027_4456# b5 0.008248f
C193 a_n1749_4456# a_n3634_3911# 0.07824f
C194 a6 sout7 5.92e-19
C195 a_n3634_3096# a_n3447_3723# 5.27e-19
C196 VDD a_n3634_4699# 1.39939f
C197 b6 sout7 2.28e-19
C198 a_n1749_522# a_n3634_1554# 0.150082f
C199 a_n2911_4863# a_n1008_4784# 4.52e-22
C200 VDD a_n2911_1718# 0.142768f
C201 a_n3634_1554# a0 6.34e-19
C202 a_n2911_4075# a_n3634_4699# 0.007995f
C203 a_n2911_5266# a_n1027_5210# 7.89e-21
C204 a_n3317_n211# VDD 1.94e-19
C205 a_n2911_4863# sout6 0.034167f
C206 a3 a_n2911_1718# 0.006839f
C207 sout5 a_n3447_4511# 4.97e-19
C208 sout2 a_n3317_2154# 4.97e-19
C209 a_n3634_4699# a_n1008_3996# 0.132333f
C210 sout2 a_n3634_2342# 0.087701f
C211 a_n1749_2853# a4 0.065929f
C212 a_n1749_3668# a_n1749_2853# 6.07e-19
C213 a_n3447_1718# a_n3634_2342# 7.67e-19
C214 a_n3634_1554# a_n3447_929# 7.65e-19
C215 VDD a4 0.604692f
C216 a_n1749_2099# a_n1730_2427# 0.00772f
C217 a_n1749_3668# VDD 0.024828f
C218 b4 a_n2911_3260# 0.073347f
C219 a_n3317_3723# sout5 0.01501f
C220 b1 a_n3634_2342# 1.32e-19
C221 a3 a4 0.041427f
C222 a_n1027_522# a_n3634_765# 0.070949f
C223 cin0 a_n3317_577# 5.59e-19
C224 a_n1749_5210# a_n3634_4699# 0.1096f
C225 a_n1749_4456# sout6 8.56e-21
C226 a_n3317_577# a_n3317_141# 0.002272f
C227 a_n1730_1639# a2 0.033659f
C228 a_n1008_1639# a_n2911_1718# 4.52e-22
C229 sout5 b4 1.91e-19
C230 b6 a_n3447_4863# 0.004422f
C231 a_n3634_3096# a_n1730_2427# 0.126176f
C232 a_n3317_3260# a5 9.53e-20
C233 a_n3634_1554# a1 0.638268f
C234 a_n3317_4075# a_n3634_4699# 7.67e-19
C235 a_n1027_2099# a_n3634_1554# 0.031007f
C236 a_n1008_62# VDD 0.618613f
C237 b3 a_n1749_2099# 0.036154f
C238 a_n1008_3181# a_n2911_3260# 4.52e-22
C239 a_n3317_5265# a_n3447_5265# 0.014951f
C240 cout7 sout7 0.084543f
C241 a_n2911_141# a_n2911_578# 0.006752f
C242 a_n2911_5266# a_n3634_5453# 0.012035f
C243 a_n1008_5538# a7 0.169292f
C244 a_n3447_2908# a_n3317_2908# 0.014951f
C245 sout4 a_n3447_3260# 0.036174f
C246 b5 a_n3634_3911# 0.614462f
C247 a_n3447_2908# a_n3447_2506# 0.002491f
C248 a_n1027_3668# a5 0.148957f
C249 VDD a_n1749_n266# 0.022884f
C250 a_n3317_929# a_n3447_929# 0.014951f
C251 a_n1027_2853# a_n3634_3911# 0.100409f
C252 b3 a_n3634_3096# 0.904296f
C253 a_n3317_2154# a_n3634_1554# 5.59e-19
C254 sout4 a_n3634_2342# 0.002135f
C255 a_n3447_2908# sout3 5.62e-19
C256 a4 a_n2911_2506# 0.007303f
C257 sout2 VDD 0.154701f
C258 a_n1749_2853# a_n1730_3181# 0.00772f
C259 a_n1749_522# a0 6.66e-19
C260 a_n3447_1718# VDD 0.01215f
C261 cin0 a_n2911_n210# 0.012035f
C262 a_n3634_1554# a_n3634_2342# 0.554879f
C263 sout2 a3 0.004592f
C264 VDD a_n1730_3181# 0.361997f
C265 a_n3634_3096# a_n1008_2427# 0.132417f
C266 a_n3447_2908# a_n3634_3911# 3.77e-20
C267 b3 a_n2911_2155# 0.007386f
C268 b1 VDD 1.0193f
C269 a_n3447_929# b2 2.39e-19
C270 a2 a_n1730_850# 4.36e-19
C271 a_n2911_5266# VDD 0.003504f
C272 a_n3447_4511# a_n3634_3911# 5.59e-19
C273 a_n3634_3096# a_n3317_2506# 8.28e-19
C274 a_n3317_929# a1 0.001237f
C275 a_n3317_4863# sout6 0.018476f
C276 a_n3317_2908# b4 0.002741f
C277 a_n2911_2909# a4 0.045558f
C278 a_n1027_5210# a7 0.148957f
C279 cin0 a_n3447_n211# 0.002776f
C280 a6 a_n3634_4699# 0.228873f
C281 b4 a_n3447_2506# 2.68e-19
C282 b6 a_n3634_4699# 0.614484f
C283 sout7 b7 0.16871f
C284 sout6 b5 2.06e-19
C285 a_n3317_3723# a_n3634_3911# 0.001568f
C286 sout1 a_n3317_577# 0.01501f
C287 a_n3317_1366# a2 0.001953f
C288 a_n1008_62# a_n2911_141# 4.52e-22
C289 a_n1027_2099# b2 0.008248f
C290 b4 sout3 0.002016f
C291 a1 b2 3.06e-20
C292 a_n1008_850# a_n1730_850# 0.032245f
C293 a_n2911_5266# a_n1749_5210# 1.46e-19
C294 cin0 sout0 0.110878f
C295 a_n2911_3724# VDD 0.002691f
C296 b4 a_n3634_3911# 0.903818f
C297 a_n3634_4699# a_n2911_3260# 1.28e-20
C298 a_n1749_3668# a6 9.55e-20
C299 a_n1749_522# a1 0.065929f
C300 sout1 a2 0.004584f
C301 cin0 a_n3447_141# 0.003618f
C302 a_n3447_4511# sout6 0.031223f
C303 sout0 a_n3317_141# 0.018476f
C304 a1 a0 0.038139f
C305 a_n3447_141# a_n3317_141# 0.014951f
C306 a2 a_n2911_1718# 0.074154f
C307 sout4 a_n1749_2853# 8.56e-21
C308 sout5 a_n3634_4699# 0.087701f
C309 a_n3447_3260# a_n3317_3260# 0.014951f
C310 VDD a_n3447_577# 9.21e-19
C311 sout4 VDD 0.155326f
C312 sout4 a3 5.92e-19
C313 a4 a_n2911_3260# 0.074154f
C314 a_n3634_1554# VDD 1.39988f
C315 b3 a_n1730_2427# 0.26536f
C316 a_n3447_4863# b7 2.68e-19
C317 a_n3317_5617# a7 0.001237f
C318 cin0 a_n1027_n266# 0.032457f
C319 VDD a_n3447_4075# 0.01215f
C320 b1 a_n2911_141# 4.44e-19
C321 a_n3634_4699# a_n2911_4512# 0.012035f
C322 a_n3634_1554# a3 0.008974f
C323 a_n3634_2342# b2 0.904036f
C324 a_n1008_3181# a_n3634_3911# 0.132272f
C325 a_n3634_5453# a7 0.226585f
C326 a_n1027_4456# a_n3634_4699# 0.070949f
C327 sout7 sout6 0.012655f
C328 a_n1008_2427# a_n1730_2427# 0.032245f
C329 a_n1730_4784# a7 4.99e-19
C330 cout7 a_n3634_4699# 0.022241f
C331 a_n1027_5210# a_n1008_5538# 0.009429f
C332 sout5 a4 5.31e-19
C333 a_n1749_3668# sout5 8.56e-21
C334 a_n2911_5617# a7 0.074154f
C335 a_n3634_5453# a5 6.34e-19
C336 cin0 b0 0.453733f
C337 a_n3634_3096# b5 0.002666f
C338 b0 a_n3317_141# 0.004341f
C339 a_n3634_5453# a_n3317_4511# 4.61e-20
C340 a_n3634_1554# a_n1008_1639# 0.041476f
C341 a_n1749_4456# a_n1730_3996# 0.004828f
C342 a_n3634_3096# a_n1027_2853# 0.080167f
C343 VDD a7 0.613943f
C344 b3 a_n1008_2427# 0.201653f
C345 a_n3447_n211# a_n3317_n211# 0.014951f
C346 a_n3317_929# VDD 0.029633f
C347 b3 a_n3317_2506# 0.004341f
C348 a_n2911_5266# a6 8.16e-19
C349 a_n2911_5266# b6 7.03e-19
C350 a_n3317_4075# a_n3447_4075# 0.014951f
C351 a_n3447_2908# a_n3634_3096# 0.002776f
C352 sout1 sout0 0.01176f
C353 a5 a_n1749_2853# 8.84e-20
C354 a_n3447_4863# sout6 0.036174f
C355 a5 VDD 0.597408f
C356 sout2 a_n2911_1367# 0.041347f
C357 b1 a_n3317_577# 0.002741f
C358 a_n3447_3723# b5 0.010473f
C359 a_n2911_4075# a5 0.074154f
C360 sout1 a_n3447_141# 1.45e-19
C361 a_n2911_141# a_n3634_1554# 1.4e-20
C362 a_n3634_4699# b7 0.003529f
C363 a_n2911_3260# a_n1730_3181# 1.25e-19
C364 b1 a_n2911_1367# 6.53e-19
C365 a1 a_n3634_2342# 6.32e-19
C366 a_n1027_2099# a_n3634_2342# 0.070949f
C367 a_n1008_62# a_n1008_850# 3.13e-19
C368 a_n3317_4511# VDD 0.001014f
C369 a_n3317_4863# a_n3317_5265# 0.002491f
C370 sout0 a_n3317_n211# 0.01501f
C371 VDD b2 1.01923f
C372 a5 a_n1008_3996# 0.169292f
C373 a_n3634_5453# a_n1008_5538# 0.041609f
C374 sout2 a2 0.119864f
C375 a_n1749_5210# a7 0.065929f
C376 a_n1749_2099# a_n1730_1639# 0.004828f
C377 a_n3317_3260# VDD 0.029633f
C378 a_n3317_2908# a4 0.001953f
C379 sout4 a_n2911_2909# 0.041347f
C380 a3 b2 8.04e-19
C381 a_n3634_3096# a_n3317_3723# 5.27e-19
C382 a_n3634_4699# a_n3634_3911# 0.554501f
C383 b1 a2 8.02e-19
C384 a_n2911_929# a_n1730_850# 1.25e-19
C385 cin0 a_n3634_765# 0.41802f
C386 a_n1749_522# VDD 0.02507f
C387 a_n2911_5617# a_n1008_5538# 4.52e-22
C388 VDD a0 0.56653f
C389 a_n3634_765# a_n3317_141# 7.67e-19
C390 a_n3634_3096# b4 0.613145f
C391 sout3 a4 0.004871f
C392 a_n2911_n210# a_n1749_n266# 1.46e-19
C393 a_n1027_3668# VDD 0.028357f
C394 a_n3317_2154# a_n3634_2342# 0.001568f
C395 a4 a_n3634_3911# 0.638144f
C396 a_n2911_3724# a_n2911_3260# 0.006297f
C397 a_n1749_3668# a_n3634_3911# 0.01644f
C398 sout1 b0 2.06e-19
C399 b2 a_n1008_1639# 0.201653f
C400 VDD a_n1008_5538# 0.635912f
C401 a_n3317_3723# a_n3447_3723# 0.014951f
C402 a_n2911_578# b0 6.54e-19
C403 a_n3447_929# VDD 0.01215f
C404 a5 a_n3317_4075# 0.001237f
C405 sout2 a_n3317_1718# 0.018476f
C406 a_n1730_3996# b5 0.26536f
C407 b1 a_n1008_850# 0.201653f
C408 a_n1027_3668# a_n1008_3996# 0.009429f
C409 a_n2911_5266# cout7 0.132214f
C410 a_n3447_1718# a_n3317_1718# 0.014951f
C411 b6 a_n3447_4075# 2.4e-19
C412 a_n3317_577# a_n3447_577# 0.014951f
C413 a_n3634_5453# a_n1027_5210# 0.080677f
C414 a_n1008_4784# a_n3634_4699# 0.041476f
C415 a_n3317_4075# a_n3317_4511# 0.002272f
C416 a_n3317_n211# b0 0.002741f
C417 a_n3634_4699# sout6 0.111002f
C418 a_n3634_1554# a_n3317_577# 4.61e-20
C419 sout1 a_n2911_929# 0.034167f
C420 a_n2911_3724# sout5 0.041347f
C421 a_n1730_5538# a7 0.033659f
C422 b4 a_n3447_3723# 4.91e-20
C423 a_n3634_3096# a_n1008_3181# 0.041609f
C424 sout4 a_n2911_3260# 0.034167f
C425 a_n3634_765# a_n1730_850# 0.056654f
C426 a_n3447_1366# a_n3634_765# 5.58e-19
C427 a_n3447_5265# sout7 0.031223f
C428 a_n3634_1554# a_n2911_1367# 0.012035f
C429 a_n3447_5617# sout7 0.036174f
C430 cin0 a_n1730_62# 0.025174f
C431 a_n1730_1639# a_n1749_1311# 0.00772f
C432 a1 VDD 0.600264f
C433 a_n1027_2099# VDD 0.030343f
C434 a_n3317_5265# sout7 0.01501f
C435 sout0 a_n1749_n266# 8.56e-21
C436 a_n1027_2099# a3 0.148957f
C437 sout4 sout5 0.011139f
C438 a_n3634_1554# a2 0.228872f
C439 a_n1008_62# a_n1027_n266# 0.009429f
C440 a_n3317_1366# a_n3634_765# 5.58e-19
C441 b3 a_n1027_2853# 0.008812f
C442 a6 a7 0.041427f
C443 VDD a_n1027_5210# 0.03928f
C444 sout5 a_n3447_4075# 0.036174f
C445 b6 a7 9.03e-19
C446 a_n2911_141# a0 0.074154f
C447 sout2 sout3 0.01176f
C448 a_n3447_3260# VDD 0.01215f
C449 b1 sout0 0.001868f
C450 a_n3447_1718# sout3 1.45e-19
C451 a_n2911_5266# b7 0.007386f
C452 a_n1008_2427# a_n1027_2853# 0.017037f
C453 a_n3447_2908# b3 6.01e-20
C454 sout1 a_n3634_765# 0.111002f
C455 a_n1027_n266# a_n1749_n266# 0.019488f
C456 a_n3317_2154# VDD 0.001014f
C457 a_n1008_62# b0 0.201653f
C458 b1 a_n3447_141# 2.4e-19
C459 a_n2911_578# a_n3634_765# 0.012035f
C460 a_n3317_5617# a_n3634_5453# 0.002421f
C461 a5 a6 0.038139f
C462 b6 a5 3.06e-20
C463 a_n3317_2154# a3 0.001953f
C464 a_n1730_3181# a_n3634_3911# 0.125729f
C465 sout2 a_n3447_2154# 4.97e-19
C466 a_n1027_2099# a_n1008_1639# 0.015383f
C467 a_n3634_2342# a_n1749_2853# 0.1096f
C468 a_n3634_1554# a_n1008_850# 0.132331f
C469 b4 a_n1730_2427# 2.04e-19
C470 VDD a_n3634_2342# 1.4001f
C471 b1 a_n1027_1311# 0.008232f
C472 a_n3447_2154# a_n3447_1718# 0.002272f
C473 a_n3447_5265# a_n3447_4863# 0.002491f
C474 a_n1749_4456# b5 4.89e-19
C475 a_n3317_4511# a6 0.001953f
C476 a3 a_n3634_2342# 0.228873f
C477 a_n3317_n211# a_n3634_765# 4.61e-20
C478 b6 a_n3317_4511# 0.002741f
C479 a_n3634_5453# a_n1730_4784# 0.126176f
C480 a_n3634_1554# a_n3317_1718# 0.002421f
C481 a_n1749_5210# a_n1027_5210# 0.019488f
C482 a_n3634_5453# a_n2911_5617# 0.019818f
C483 b1 a_n1027_n266# 1.74e-19
C484 a_n1749_n266# b0 0.036154f
C485 a5 a_n2911_3260# 0.00651f
C486 a_n1749_1311# a_n1730_850# 0.004814f
C487 a_n1730_5538# a_n1008_5538# 0.032245f
C488 a_n3317_929# a2 1.03e-19
C489 cin0 a_n1027_522# 0.030701f
C490 a_n3634_3096# a_n3634_4699# 0.017875f
C491 a_n1749_2099# a4 1.06e-19
C492 sout4 a_n3317_2908# 0.01501f
C493 a_n2911_141# a1 0.006839f
C494 a_n3317_5617# VDD 0.029633f
C495 a_n2911_1367# b2 0.007386f
C496 b3 b4 0.023614f
C497 a_n3634_3096# a_n2911_1718# 1.4e-20
C498 a_n1027_4456# a7 1.95e-19
C499 a_n1749_522# a_n3317_577# 8.29e-21
C500 a_n1027_3668# a6 1.76e-19
C501 b3 a_n1730_1639# 1.75e-19
C502 a_n3634_5453# VDD 1.42388f
C503 a5 sout5 0.119864f
C504 b6 a_n1027_3668# 1.74e-19
C505 sout4 a_n3447_2506# 1.59e-19
C506 b1 b0 0.021185f
C507 a_n3317_1366# a_n1749_1311# 8.29e-21
C508 a_n2911_3724# a_n3634_3911# 0.012035f
C509 a_n3634_2342# a_n1008_1639# 0.132333f
C510 cout7 a7 0.636064f
C511 sout0 a_n3447_577# 4.97e-19
C512 a_n2911_4075# a_n3634_5453# 1.4e-20
C513 a_n1730_4784# VDD 0.361997f
C514 a2 b2 1.02288f
C515 a_n1008_2427# b4 7.93e-20
C516 sout5 a_n3317_4511# 4.97e-19
C517 a_n2911_5617# VDD 0.142768f
C518 a5 a_n2911_4512# 7.59e-19
C519 a_n2911_2155# a_n2911_1718# 0.006752f
C520 a_n3634_1554# sout0 0.003071f
C521 a_n3447_141# a_n3447_577# 0.002272f
C522 a5 a_n1027_4456# 0.003191f
C523 sout4 sout3 0.012655f
C524 a_n3634_3096# a4 0.226232f
C525 b1 a_n2911_929# 0.073347f
C526 a_n3317_3260# sout5 1.9e-19
C527 a_n1008_62# a_n3634_765# 0.132333f
C528 a_n1749_3668# a_n3634_3096# 0.064247f
C529 a_n1749_522# a2 9.52e-20
C530 a_n3634_1554# sout3 0.001929f
C531 a_n3447_3723# a_n3634_4699# 3.77e-20
C532 sout4 a_n3634_3911# 0.087482f
C533 a_n3634_1554# a_n1027_1311# 0.070763f
C534 a_n3634_2342# a_n2911_2506# 0.019818f
C535 VDD a_n1749_2853# 0.025442f
C536 a_n3447_4075# a_n3634_3911# 0.003618f
C537 a_n3634_5453# a_n1749_5210# 0.016361f
C538 a_n3447_5265# a_n3634_4699# 6.03e-19
C539 a_n3447_2154# a_n3634_1554# 5.59e-19
C540 a3 a_n1749_2853# 7.31e-19
C541 b2 a_n1008_850# 7.05e-20
C542 a3 VDD 0.60027f
C543 a_n1008_2427# a_n1008_3181# 3.29e-19
C544 a_n3634_765# a_n1749_n266# 0.15071f
C545 a_n2911_4075# VDD 0.142768f
C546 a_n1730_4784# a_n1749_5210# 0.005351f
C547 a_n3317_5265# a_n3634_4699# 6.03e-19
C548 b2 a_n3317_1718# 0.004341f
C549 a_n2911_2909# a_n3634_2342# 0.001648f
C550 VDD a_n1008_3996# 0.627786f
C551 a_n3317_577# a1 0.001953f
C552 a6 a_n1027_5210# 0.003484f
C553 sout2 a_n3634_765# 0.001923f
C554 a_n1027_2853# b5 1.61e-19
C555 a_n2911_4075# a_n1008_3996# 4.52e-22
C556 b6 a_n1027_5210# 0.008812f
C557 a_n1027_3668# a_n1027_4456# 0.004712f
C558 b0 a_n3447_577# 5.36e-20
C559 b7 a7 1.02288f
C560 a_n2911_1367# a1 7.57e-19
C561 b1 a_n3634_765# 0.614484f
C562 a_n2911_n210# a0 0.045558f
C563 a_n3634_1554# b0 1.33e-19
C564 a_n1749_5210# VDD 0.025442f
C565 a_n1008_62# a_n1730_62# 0.032245f
C566 VDD a_n1008_1639# 0.627791f
C567 a_n1027_2099# a2 0.003191f
C568 a1 a2 0.038052f
C569 a_n3447_4511# b5 5.36e-20
C570 cout7 a_n1008_5538# 0.122302f
C571 a_n3634_4699# a_n1730_3996# 0.125919f
C572 a_n3447_4075# sout6 1.45e-19
C573 a3 a_n1008_1639# 2.72e-19
C574 a_n1027_522# a_n2911_578# 7.89e-21
C575 sout2 a_n3634_3096# 0.003071f
C576 a_n3634_1554# a_n2911_929# 0.007989f
C577 a_n3634_5453# a_n1730_5538# 0.05695f
C578 a_n3634_3096# a_n1730_3181# 0.05695f
C579 a_n3317_4075# VDD 0.029633f
C580 a5 a_n3634_3911# 0.228839f
C581 a_n1749_n266# a_n1730_62# 0.00772f
C582 a_n3317_3723# b5 0.002741f
C583 a_n3317_4863# sout7 2.25e-19
C584 sout3 b2 2.06e-19
C585 a_n2911_5617# a_n1730_5538# 1.25e-19
C586 a_n1730_2427# a4 4.99e-19
C587 VDD a_n2911_2506# 0.142768f
C588 a_n2911_1367# a_n3634_2342# 0.132214f
C589 a_n3447_3260# sout5 1.35e-19
C590 a_n3317_4511# a_n3634_3911# 5.59e-19
C591 a_n1749_3668# a_n1730_3996# 0.00772f
C592 a_n2911_141# VDD 0.142768f
C593 a1 a_n1008_850# 0.169292f
C594 a3 a_n2911_2506# 0.074154f
C595 a_n1027_1311# b2 0.177862f
C596 sout0 a0 0.119864f
C597 b3 a_n2911_1718# 4.44e-19
C598 a_n3317_3260# a_n3634_3911# 7.22e-19
C599 a_n1008_4784# a7 2.95e-19
C600 a_n3447_2154# b2 5.36e-20
C601 b4 b5 0.019641f
C602 a_n1027_5210# a_n1027_4456# 0.004936f
C603 a_n2911_4863# a_n3634_4699# 0.019818f
C604 a_n3634_5453# a6 0.638448f
C605 b1 a_n1730_62# 1.75e-19
C606 a2 a_n3634_2342# 0.638273f
C607 b6 a_n3634_5453# 0.904296f
C608 sout6 a7 0.004871f
C609 a_n2911_2909# a_n1749_2853# 1.46e-19
C610 cout7 a_n1027_5210# 0.100336f
C611 a_n3634_765# a_n3447_577# 0.002776f
C612 b4 a_n1027_2853# 0.177862f
C613 sout2 a_n1749_1311# 8.56e-21
C614 a_n2911_2909# VDD 0.003504f
C615 a6 a_n1730_4784# 0.033659f
C616 VDD a_n1730_5538# 0.362606f
C617 b6 a_n1730_4784# 0.26536f
C618 a_n2911_2909# a3 8.16e-19
C619 a_n3634_1554# a_n3634_765# 0.554539f
C620 b7 a_n1008_5538# 0.201653f
C621 a_n2911_3724# a_n3634_3096# 0.001416f
C622 b3 a4 9.03e-19
C623 b1 a_n1749_1311# 4.86e-19
C624 a_n1027_3668# a_n3634_3911# 0.066859f
C625 a_n1749_2099# a_n3634_1554# 0.07824f
C626 a5 sout6 5.56e-19
C627 a_n3447_2908# b4 0.010473f
C628 a_n1027_n266# a0 0.148957f
C629 a_n1008_62# a_n1027_522# 0.015383f
C630 a_n1008_3181# b5 6.48e-20
C631 a_n3317_4863# a_n3447_4863# 0.014951f
C632 a_n1749_4456# a_n3634_4699# 0.01644f
C633 a_n1008_2427# a4 2.95e-19
C634 a_n3317_4511# sout6 0.01501f
C635 a_n3317_2154# a_n3317_1718# 0.002272f
C636 sout4 a_n3634_3096# 0.111015f
C637 a6 VDD 0.60027f
C638 b6 VDD 1.0193f
C639 a_n1027_2853# a_n1008_3181# 0.009429f
C640 a4 a_n3317_2506# 1.15e-19
C641 a_n1749_522# b0 4.89e-19
C642 a_n3634_5453# sout5 0.003071f
C643 a_n3634_2342# a_n3317_1718# 7.67e-19
C644 a_n1749_5210# a_n1730_5538# 0.00772f
C645 a_n3634_3096# a_n3634_1554# 0.019576f
C646 a_n2911_4075# a6 0.006839f
C647 sout0 a1 0.004592f
C648 a_n2911_929# b2 4.43e-19
C649 a_n2911_4075# b6 4.44e-19
C650 b0 a0 1.02288f
C651 a_n3317_577# VDD 0.001014f
C652 a6 a_n1008_3996# 2.72e-19
C653 b6 a_n1008_3996# 7.07e-20
C654 a_n3634_5453# a_n2911_4512# 0.132214f
C655 a_n1027_5210# b7 0.177862f
C656 a_n3634_5453# a_n1027_4456# 0.100409f
C657 a1 a_n1027_1311# 0.003184f
C658 a_n1027_2099# a_n1027_1311# 0.004712f
C659 a_n1749_4456# a_n1749_3668# 6.28e-19
C660 a_n2911_1367# VDD 0.003001f
C661 a_n2911_2155# a_n3634_1554# 0.001512f
C662 VDD a_n2911_3260# 0.142768f
C663 a_n3317_929# a_n3634_765# 0.002421f
C664 a_n3634_5453# cout7 0.290454f
C665 sout4 a_n3447_3723# 4.53e-19
C666 a_n1008_4784# a_n1008_5538# 3.29e-19
C667 b1 a_n1027_522# 0.177862f
C668 a_n3317_2908# a_n3634_2342# 6.03e-19
C669 a6 a_n1749_5210# 7.31e-19
C670 a1 a_n1027_n266# 1.76e-19
C671 a2 VDD 0.600149f
C672 b6 a_n1749_5210# 6.13e-19
C673 a_n2911_2909# a_n2911_2506# 0.00742f
C674 a3 a2 0.038139f
C675 sout5 VDD 0.154308f
C676 a_n3447_2506# a_n3634_2342# 0.003618f
C677 a_n2911_5617# cout7 0.005623f
C678 a_n3634_1554# a_n1749_1311# 0.01644f
C679 a_n3447_3260# a_n3634_3911# 7.22e-19
C680 a_n3317_2154# sout3 0.01501f
C681 sout2 b3 0.001868f
C682 a_n2911_4075# sout5 0.034167f
C683 b3 a_n3447_1718# 2.4e-19
C684 a_n3634_765# b2 0.002985f
C685 a_n3317_4075# a6 1.04e-19
C686 VDD a_n2911_4512# 0.003014f
C687 sout3 a_n3634_2342# 0.111002f
C688 VDD a_n1027_4456# 0.030343f
C689 a_n1749_2099# b2 4.89e-19
C690 a1 b0 8.04e-19
C691 a_n2911_4075# a_n2911_4512# 0.006752f
C692 b4 a_n1008_3181# 0.201653f
C693 a_n3317_2154# a_n3447_2154# 0.014951f
C694 a_n3317_4863# a_n3634_4699# 0.002421f
C695 sout7 a_n3447_4863# 1.59e-19
C696 a_n2911_4863# a_n2911_5266# 0.00742f
C697 a_n3634_2342# a_n3634_3911# 0.022241f
C698 a_n1027_1311# a_n3634_2342# 0.100409f
C699 cout7 VDD 0.222845f
C700 a_n1749_522# a_n3634_765# 0.01644f
C701 a_n3634_3096# a5 0.008181f
C702 VDD a_n1008_850# 0.627791f
C703 cin0 a_n3317_141# 0.002421f
C704 a_n3447_2154# a_n3634_2342# 0.002776f
C705 a_n3634_765# a0 0.639831f
C706 a_n3634_4699# b5 0.904036f
C707 a_n1027_4456# a_n1008_3996# 0.015383f
C708 a2 a_n1008_1639# 0.169292f
C709 a1 a_n2911_929# 0.074154f
C710 a_n1008_4784# a_n1027_5210# 0.017037f
C711 VDD a_n3317_1718# 0.029633f
C712 a_n3317_5617# b7 0.004341f
C713 a3 a_n3317_1718# 1.04e-19
C714 a_n3634_3096# b2 1.33e-19
C715 a_n3634_5453# b7 0.613254f
C716 a_n3634_3096# a_n3317_3260# 0.002421f
C717 a_n1730_4784# b7 2.04e-19
C718 a_n3447_n211# VDD 1.02e-19
C719 a_n3447_929# a_n3634_765# 0.003618f
C720 a_n2911_5617# b7 0.073347f
C721 sout5 a_n3317_4075# 0.018476f
C722 a4 b5 2.82e-20
C723 a_n3634_5453# a_n3634_3911# 0.019576f
C724 a_n1027_522# a_n3634_1554# 0.100409f
C725 a_n1749_3668# b5 0.036154f
C726 a_n2911_2155# b2 6.54e-19
C727 a_n3317_5265# a7 0.001953f
C728 cout7 a_n1749_5210# 0.150082f
C729 a_n3317_2908# a_n1749_2853# 8.29e-21
C730 a_n3447_4511# a_n3634_4699# 0.002776f
C731 a_n3317_2908# VDD 0.001153f
C732 a_n1008_1639# a_n1008_850# 3.12e-19
C733 a_n1027_2853# a4 0.148957f
C734 a_n3634_3096# a_n1027_3668# 0.024499f
C735 VDD a_n3447_2506# 0.01215f
C736 sout4 b3 2.28e-19
C737 a_n2911_929# a_n3634_2342# 1.4e-20
C738 b6 a6 1.02288f
C739 sout0 VDD 0.15053f
C740 VDD b7 1.02719f
C741 b3 a_n3634_1554# 0.002999f
C742 a1 a_n3634_765# 0.228873f
C743 a_n1749_522# a_n1730_62# 0.004828f
C744 a_n3317_3723# a_n3634_4699# 4.61e-20
C745 a_n1749_1311# b2 0.036154f
C746 a_n1027_2099# a_n1749_2099# 0.019488f
C747 a_n1730_62# a0 0.033659f
C748 sout3 VDD 0.154726f
C749 VDD a_n3447_141# 0.01215f
C750 sout3 a3 0.119864f
C751 a_n1749_2853# a_n3634_3911# 0.150082f
C752 sout7 a_n3634_4699# 0.002135f
C753 a_n1749_522# a_n1749_1311# 6.27e-19
C754 VDD a_n3634_3911# 1.39782f
C755 a_n1027_1311# VDD 0.030264f
C756 sout4 a_n3317_2506# 2.25e-19
C757 a_n3634_5453# a_n1008_4784# 0.132417f
C758 a3 a_n3634_3911# 7.04e-19
C759 a3 a_n1027_1311# 1.76e-19
C760 b4 a_n3634_4699# 1.2e-19
C761 a_n3447_2154# VDD 9.21e-19
C762 a_n2911_4075# a_n3634_3911# 0.019818f
C763 a_n3634_5453# sout6 0.088013f
C764 a_n1008_4784# a_n1730_4784# 0.032245f
C765 a_n1730_1639# a_n2911_1718# 1.25e-19
C766 cin0 sout1 0.001929f
C767 VDD a_n1027_n266# 0.008314f
C768 a_n1749_3668# a_n3317_3723# 8.29e-21
C769 a_n1027_2099# a_n3634_3096# 0.100409f
C770 cin0 a_n2911_578# 0.001512f
C771 a_n1730_4784# sout6 7.26e-20
C772 a_n1008_3996# a_n3634_3911# 0.04147f
C773 a5 a_n1730_3996# 0.033659f
C774 a_n1749_5210# b7 0.036154f
C775 cout7 a_n1730_5538# 0.122573f
C776 sout1 a_n3317_141# 2.04e-19
C777 sout5 a6 0.004592f
C778 a_n3317_2154# a_n1749_2099# 8.29e-21
C779 b6 sout5 0.001868f
C780 cin0 a_n3317_n211# 0.001568f
C781 a_n3634_765# a_n3634_2342# 0.019507f
C782 b4 a4 1.02288f
C783 a_n1027_2099# a_n2911_2155# 7.89e-21
C784 a_n1749_3668# b4 4.15e-19
C785 a_n1749_2099# a_n3634_2342# 0.01644f
C786 b5 a_n1730_3181# 1.55e-19
C787 a6 a_n2911_4512# 0.045558f
C788 a_n2911_4863# a7 0.007303f
C789 VDD b0 1.00565f
C790 b6 a_n2911_4512# 0.007386f
C791 a_n3447_3260# a_n3634_3096# 0.003618f
C792 a_n3447_1366# a_n3317_1366# 0.014951f
C793 a_n2911_1367# a2 0.045558f
C794 a6 a_n1027_4456# 0.148957f
C795 a_n1027_1311# a_n1008_1639# 0.009429f
C796 a_n1008_4784# VDD 0.627795f
C797 a1 a_n1730_62# 4.38e-19
C798 a_n1027_522# b2 1.74e-19
C799 b6 a_n1027_4456# 0.177862f
C800 VDD sout6 0.154726f
C801 a6 cout7 7.04e-19
C802 a_n3317_2154# a_n3634_3096# 4.61e-20
C803 a_n3447_4863# a_n3634_4699# 0.003618f
C804 b6 cout7 1.53e-19
C805 a_n2911_929# VDD 0.142768f
C806 a_n1008_4784# a_n1008_3996# 3.13e-19
C807 a_n2911_141# sout0 0.034167f
C808 a_n3317_4075# a_n3634_3911# 0.002421f
C809 a_n1749_522# a_n1027_522# 0.019488f
C810 a1 a_n1749_1311# 6.65e-19
C811 a_n3634_3096# a_n3634_2342# 0.568869f
C812 sout1 a_n1730_850# 7.26e-20
C813 sout3 a_n2911_2506# 0.034167f
C814 a_n1027_522# a0 0.003191f
C815 a_n3447_1366# sout1 4.95e-19
C816 a4 a_n1008_3181# 0.169292f
C817 b3 b2 0.021185f
C818 a_n2911_2506# a_n3634_3911# 1.57e-20
C819 a_n1749_4456# a7 1.06e-19
C820 a_n3447_3260# a_n3447_3723# 0.002124f
C821 b7 a_n1730_5538# 0.26536f
C822 a_n2911_2155# a_n3634_2342# 0.012035f
C823 cin0 a_n1008_62# 0.029885f
C824 a_n2911_3724# b5 0.007386f
C825 a_n3317_1366# sout1 4.95e-19
C826 a2 a_n1008_850# 2.72e-19
C827 a_n2911_2909# a_n3634_3911# 0.132214f
C828 a_n1749_4456# a5 6.66e-19
C829 a2 a_n3317_1718# 0.001237f
C830 a_n1027_4456# a_n2911_4512# 7.89e-21
C831 a_n1749_1311# a_n3634_2342# 0.150082f
C832 sout4 b5 0.001765f
C833 cin0 a_n1749_n266# 0.009704f
C834 VDD a_n3634_765# 1.39408f
C835 a_n3317_4075# sout6 2.04e-19
C836 a_n1749_4456# a_n3317_4511# 8.29e-21
C837 sout2 a_n1730_1639# 7.26e-20
C838 a_n2911_5266# sout7 0.041347f
C839 a_n1749_2099# a_n1749_2853# 6.57e-19
C840 a6 b7 3.42e-20
C841 b6 b7 0.023614f
C842 b4 a_n1730_3181# 0.26536f
C843 sout1 a_n2911_578# 0.041347f
C844 a_n1749_2099# VDD 0.02507f
C845 a_n2911_141# b0 0.073347f
C846 a_n3447_4075# b5 0.004422f
C847 a_n1749_2099# a3 0.065929f
C848 a_n1027_522# a1 0.148957f
C849 sout0 a_n3317_577# 4.97e-19
C850 a6 a_n3634_3911# 0.008974f
C851 b6 a_n3634_3911# 0.002999f
C852 cin0 b1 0.002194f
C853 sout4 a_n3447_2908# 0.031223f
C854 a_n3634_3096# a_n1749_2853# 0.016361f
C855 a_n3634_3096# VDD 1.40508f
C856 b3 a_n1027_2099# 0.177862f
C857 a_n3634_3096# a3 0.638448f
C858 a_n3634_5453# a_n3447_5265# 0.002776f
C859 a_n3317_5617# a_n3447_5617# 0.014951f
C860 a_n1008_3181# a_n1730_3181# 0.032245f
C861 a_n3447_4511# a_n3447_4075# 0.002272f
C862 a_n3317_4863# a7 1.15e-19
C863 a_n2911_1367# a_n1027_1311# 7.89e-21
C864 a_n3447_5617# a_n3634_5453# 0.003618f
C865 a_n2911_3260# a_n3634_3911# 0.007849f
C866 a_n3317_5265# a_n3634_5453# 0.001568f
C867 a_n1730_2427# a_n3634_2342# 0.056654f
C868 a_n3634_4699# a4 5.86e-19
C869 a_n2911_3724# b4 6.2e-19
C870 a_n1749_3668# a_n3634_4699# 0.150082f
C871 sout3 a2 5.56e-19
C872 a_n1027_2099# a_n1008_2427# 0.009429f
C873 a_n2911_2155# VDD 0.003014f
C874 sout4 a_n3317_3723# 4.53e-19
C875 a_n2911_2155# a3 0.045558f
C876 a2 a_n1027_1311# 0.148957f
C877 VDD a_n1730_62# 0.361996f
C878 a_n1008_4784# a6 0.169292f
C879 b6 a_n1008_4784# 0.201653f
C880 a_n1027_4456# b7 1.93e-19
C881 sout5 a_n3634_3911# 0.110993f
C882 sout2 a_n3447_1366# 0.031223f
C883 a_n3447_3723# VDD 8.31e-19
C884 a6 sout6 0.119864f
C885 b6 sout6 0.16871f
C886 a_n3317_2154# b3 0.002741f
C887 sout4 b4 0.16871f
C888 a5 b5 1.02288f
C889 b1 a_n1730_850# 0.26536f
C890 VDD a_n1749_1311# 0.02506f
C891 cout7 b7 0.894798f
C892 a_n2911_141# a_n3634_765# 0.007995f
C893 b1 a_n3447_1366# 5.34e-20
C894 a_n1749_3668# a4 6.22e-19
C895 a_n2911_4512# a_n3634_3911# 0.001512f
C896 a_n3447_5265# VDD 0.00106f
C897 b3 a_n3634_2342# 0.614484f
C898 a3 a_n1749_1311# 9.55e-20
C899 a_n1730_1639# a_n3634_1554# 0.056654f
C900 a_n1027_4456# a_n3634_3911# 0.031007f
C901 sout0 a_n2911_n210# 0.041347f
C902 a_n3447_5617# VDD 0.01215f
C903 a5 a_n1027_2853# 1.63e-19
C904 a_n3317_5265# VDD 0.001153f
C905 cin0 a_n3447_577# 5.59e-19
C906 sout2 a_n3317_1366# 0.01501f
C907 sout3 a_n3317_1718# 2.04e-19
C908 a_n1027_1311# a_n1008_850# 0.015338f
C909 cin0 a_n3634_1554# 0.016487f
C910 a_n1008_2427# a_n3634_2342# 0.041476f
C911 a_n2911_1367# a_n2911_929# 0.006734f
C912 a_n3447_n211# sout0 0.031223f
C913 a_n3634_2342# a_n3317_2506# 0.002421f
C914 a_n3634_3096# a_n2911_2506# 0.008197f
C915 sout2 sout1 0.011736f
C916 a_n3317_n211# a_n1749_n266# 8.29e-21
C917 sout5 sout6 0.01176f
C918 a_n2911_n210# a_n1027_n266# 7.89e-21
C919 a2 a_n2911_929# 0.006826f
C920 sout7 a7 0.119864f
C921 a_n1027_3668# b5 0.177862f
C922 a_n1730_2427# a_n1749_2853# 0.005351f
C923 a_n3447_4511# a_n3317_4511# 0.014951f
C924 b1 sout1 0.16871f
C925 b1 a_n2911_578# 0.007386f
C926 a_n3317_2908# sout3 5.62e-19
C927 a_n3317_5265# a_n1749_5210# 8.29e-21
C928 a_n1730_2427# VDD 0.361997f
C929 VDD a_n1730_3996# 0.361997f
C930 sout2 a_n2911_1718# 0.034167f
C931 a_n1008_4784# a_n1027_4456# 0.009429f
C932 a_n2911_4863# a_n3634_5453# 0.008197f
C933 a_n3634_3096# a_n2911_2909# 0.012035f
C934 a_n2911_4512# sout6 0.041347f
C935 a_n1730_2427# a3 0.033659f
C936 a_n3317_3723# a5 0.001953f
C937 a_n1027_3668# a_n1027_2853# 0.004548f
C938 a_n2911_4075# a_n1730_3996# 1.25e-19
C939 sout3 a_n3447_2506# 0.036174f
C940 a_n2911_5266# a_n3634_4699# 0.001648f
C941 a_n2911_4863# a_n1730_4784# 1.25e-19
C942 a_n1027_522# VDD 0.030343f
C943 a_n3317_2908# a_n3634_3911# 4.61e-20
C944 a_n2911_141# a_n1730_62# 1.25e-19
C945 cout7 sout6 0.003273f
C946 sout0 a_n3447_141# 0.036174f
C947 a_n2911_n210# b0 0.007386f
C948 a_n1730_3996# a_n1008_3996# 0.032245f
C949 a_n3317_577# a_n3634_765# 0.001568f
C950 a_n3634_1554# a_n1730_850# 0.125912f
C951 a5 b4 7.37e-19
C952 a_n3317_3260# a_n3317_3723# 0.002124f
C953 a_n3447_1366# a_n3634_1554# 0.002776f
C954 a_n2911_929# a_n1008_850# 4.52e-22
C955 a_n2911_1367# a_n3634_765# 0.001509f
C956 a4 a_n1730_3181# 0.033659f
C957 a_n1749_3668# a_n1730_3181# 0.004475f
C958 b3 a_n1749_2853# 6.13e-19
C959 b3 VDD 1.0193f
C960 sout3 a_n3634_3911# 0.003273f
C961 a_n1749_4456# a_n3634_5453# 0.150082f
C962 a_n3447_n211# b0 0.010473f
C963 b3 a3 1.02288f
C964 a_n3447_2154# sout3 0.031223f
C965 a_n2911_4863# VDD 0.142768f
C966 a2 a_n3634_765# 0.008942f
C967 a_n1730_1639# b2 0.26536f
C968 a_n3317_3260# b4 0.004341f
C969 a_n3317_1366# a_n3634_1554# 0.001568f
C970 a_n1749_4456# a_n1730_4784# 0.00772f
C971 a_n1749_2099# a2 6.66e-19
C972 a_n2911_3724# a_n3634_4699# 0.132214f
C973 a_n1027_2099# a_n1027_2853# 0.004936f
C974 a_n1008_2427# VDD 0.627795f
C975 a_n1008_2427# a3 0.169292f
C976 VDD a_n3317_2506# 0.029633f
C977 a5 a_n1008_3181# 2.56e-19
C978 a_n3634_3096# a_n2911_3260# 0.019818f
C979 sout1 a_n3447_577# 0.031223f
C980 a3 a_n3317_2506# 0.001237f
C981 a_n3447_3260# b5 2.2e-19
C982 sout0 b0 0.16871f
C983 b1 a_n1008_62# 7.07e-20
C984 a_n1008_4784# b7 7.93e-20
C985 a_n1027_3668# b4 0.007851f
C986 sout1 a_n3634_1554# 0.087693f
C987 sout4 a_n3634_4699# 0.002928f
C988 cin0 a_n1749_522# 0.076779f
C989 a_n3634_1554# a_n2911_578# 0.132214f
C990 a_n1730_2427# a_n2911_2506# 1.25e-19
C991 a_n3634_3096# a2 6.34e-19
C992 b0 a_n3447_141# 0.004422f
C993 sout6 b7 0.002016f
C994 a_n2911_3724# a4 7.18e-19
C995 b3 a_n1008_1639# 7.07e-20
C996 cin0 a0 0.089922f
C997 a_n3634_765# a_n1008_850# 0.041476f
C998 a_n1749_4456# VDD 0.02507f
C999 a_n1749_3668# a_n2911_3724# 1.46e-19
C1000 a_n3634_3096# sout5 0.001786f
C1001 a_n3634_4699# a_n3447_4075# 7.67e-19
C1002 a_n3634_1554# a_n2911_1718# 0.019818f
C1003 b6 a_n3447_5265# 6.01e-20
C1004 a_n2911_n210# a_n3634_765# 0.132214f
C1005 a_n3317_141# a0 0.001237f
C1006 a_n2911_2155# a2 7.59e-19
C1007 sout6 a_n3634_3911# 0.001929f
C1008 a_n1008_2427# a_n1008_1639# 3.13e-19
C1009 a_n1027_2853# a_n3634_2342# 0.046544f
C1010 sout0 GND 0.525447f
C1011 a0 GND 1.80776f
C1012 b0 GND 1.19407f
C1013 cin0 GND 1.78933f
C1014 sout1 GND 0.506031f
C1015 a1 GND 1.72363f
C1016 b1 GND 1.16061f
C1017 sout2 GND 0.506035f
C1018 a2 GND 1.72375f
C1019 b2 GND 1.16066f
C1020 sout3 GND 0.504801f
C1021 a3 GND 1.72054f
C1022 b3 GND 1.15824f
C1023 sout4 GND 0.50553f
C1024 a4 GND 1.71799f
C1025 b4 GND 1.15769f
C1026 sout5 GND 0.506987f
C1027 a5 GND 1.72869f
C1028 b5 GND 1.16334f
C1029 sout6 GND 0.504801f
C1030 a6 GND 1.72044f
C1031 b6 GND 1.15824f
C1032 sout7 GND 0.53061f
C1033 cout7 GND 1.10073f
C1034 a7 GND 1.71991f
C1035 b7 GND 1.18454f
C1036 VDD GND 38.523304f
C1037 a_n1027_n266# GND 0.594926f
C1038 a_n1749_n266# GND 0.369592f
C1039 a_n2911_n210# GND 0.266617f
C1040 a_n3317_n211# GND 0.034564f
C1041 a_n3447_n211# GND 0.015853f
C1042 a_n1008_62# GND 0.080444f
C1043 a_n1730_62# GND 0.019295f
C1044 a_n2911_141# GND 0.029159f
C1045 a_n3317_141# GND 0.005769f
C1046 a_n3447_141# GND 0.005769f
C1047 a_n1027_522# GND 0.502641f
C1048 a_n1749_522# GND 0.301881f
C1049 a_n2911_578# GND 0.255365f
C1050 a_n3317_577# GND 0.031205f
C1051 a_n3447_577# GND 0.012494f
C1052 a_n1008_850# GND 0.08001f
C1053 a_n1730_850# GND 0.019302f
C1054 a_n2911_929# GND 0.029181f
C1055 a_n3317_929# GND 0.005773f
C1056 a_n3447_929# GND 0.005773f
C1057 a_n3634_765# GND 3.16016f
C1058 a_n1027_1311# GND 0.502859f
C1059 a_n1749_1311# GND 0.302052f
C1060 a_n2911_1367# GND 0.25539f
C1061 a_n3317_1366# GND 0.031213f
C1062 a_n3447_1366# GND 0.012502f
C1063 a_n1008_1639# GND 0.079985f
C1064 a_n1730_1639# GND 0.019295f
C1065 a_n2911_1718# GND 0.029159f
C1066 a_n3317_1718# GND 0.005769f
C1067 a_n3447_1718# GND 0.005769f
C1068 a_n3634_1554# GND 3.04745f
C1069 a_n1027_2099# GND 0.502335f
C1070 a_n1749_2099# GND 0.301832f
C1071 a_n2911_2155# GND 0.255365f
C1072 a_n3317_2154# GND 0.031205f
C1073 a_n3447_2154# GND 0.012494f
C1074 a_n1008_2427# GND 0.079084f
C1075 a_n1730_2427# GND 0.019017f
C1076 a_n2911_2506# GND 0.028401f
C1077 a_n3317_2506# GND 0.005645f
C1078 a_n3447_2506# GND 0.005645f
C1079 a_n3634_2342# GND 3.10362f
C1080 a_n1027_2853# GND 0.494768f
C1081 a_n1749_2853# GND 0.295821f
C1082 a_n2911_2909# GND 0.254429f
C1083 a_n3317_2908# GND 0.030923f
C1084 a_n3447_2908# GND 0.012212f
C1085 a_n1008_3181# GND 0.08064f
C1086 a_n1730_3181# GND 0.019504f
C1087 a_n2911_3260# GND 0.029741f
C1088 a_n3317_3260# GND 0.005868f
C1089 a_n3447_3260# GND 0.005868f
C1090 a_n3634_3096# GND 3.00165f
C1091 a_n1027_3668# GND 0.508501f
C1092 a_n1749_3668# GND 0.306361f
C1093 a_n2911_3724# GND 0.256028f
C1094 a_n3317_3723# GND 0.031405f
C1095 a_n3447_3723# GND 0.012694f
C1096 a_n1008_3996# GND 0.080002f
C1097 a_n1730_3996# GND 0.019295f
C1098 a_n2911_4075# GND 0.029159f
C1099 a_n3317_4075# GND 0.005769f
C1100 a_n3447_4075# GND 0.005769f
C1101 a_n3634_3911# GND 3.06392f
C1102 a_n1027_4456# GND 0.502335f
C1103 a_n1749_4456# GND 0.301832f
C1104 a_n2911_4512# GND 0.255365f
C1105 a_n3317_4511# GND 0.031205f
C1106 a_n3447_4511# GND 0.012494f
C1107 a_n1008_4784# GND 0.079084f
C1108 a_n1730_4784# GND 0.019017f
C1109 a_n2911_4863# GND 0.028401f
C1110 a_n3317_4863# GND 0.005645f
C1111 a_n3447_4863# GND 0.005645f
C1112 a_n3634_4699# GND 3.10568f
C1113 a_n1027_5210# GND 0.488314f
C1114 a_n1749_5210# GND 0.296769f
C1115 a_n2911_5266# GND 0.254429f
C1116 a_n3317_5265# GND 0.030923f
C1117 a_n3447_5265# GND 0.012212f
C1118 a_n1008_5538# GND 0.062447f
C1119 a_n1730_5538# GND 0.022886f
C1120 a_n2911_5617# GND 0.044307f
C1121 a_n3317_5617# GND 0.008258f
C1122 a_n3447_5617# GND 0.008258f
C1123 a_n3634_5453# GND 3.28791f
.ends
