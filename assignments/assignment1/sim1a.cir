.control
  dc Vin 0 1.8 0.01

  let w_val = 0.42u
  let l_val = 0.15u

  * Simulation data
  let ids_sim = -i(vin)

  * Analytical parameters
  let vgs = net1
  let vt_n = 0.7
  let meu_n = 0.025
  let cox_n = 8.34e-3
  let vsat_n = 8e4

  let vgt = max(0, vgs - vt_n)

  let EsatL = (vsat_n * l_val) / meu_n

  let vdsat = (vgt * EsatL) / (vgt + EsatL + 1e-12)

  let ids_anal = meu_n * cox_n * (w_val / l_val) * (vgt * vdsat - 0.5 * vdsat^2)

  *computing and printing the error
  let pct_error = abs((ids_sim - ids_anal) / (ids_sim + 1e-12)) * 100
  print mean(pct_error)

  plot ids_sim ids_anal vs vgs
.endc
