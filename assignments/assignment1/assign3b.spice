** sch_path: /home/joyen/ee5311/workdir/EE5311/assignments/assignment1/assign3b.sch
**.subckt assign3b
XM1 Vds GND VDD VDD sky130_fd_pr__pfet_01v8 L=0.15 W=0.42 nf=1 ad='int((nf+1)/2) * W/nf * 0.29' as='int((nf+2)/2) * W/nf * 0.29' pd='2*int((nf+1)/2) * (W/nf + 0.29)'
+ ps='2*int((nf+2)/2) * (W/nf + 0.29)' nrd='0.29 / W' nrs='0.29 / W' sa=0 sb=0 sd=0 mult=1
Vsrc VDD GND 1.8
Vds Vds GND PULSE (1.8 0 0 10p 10p 1 1)
C1 Vds GND 100f
**** begin user architecture code

.include sim3b.cir

.lib /cad/share/pdk/sky130B/libs.tech/combined/sky130.lib.spice tt
**** end user architecture code
**.ends
.GLOBAL VDD
.GLOBAL GND
.end
