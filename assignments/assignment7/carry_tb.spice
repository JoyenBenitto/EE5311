** sch_path: /home/joyen/ee5311/EE5311/assignments/assignment7/carry_tb.sch
**.subckt carry_tb
x1 VDD a b c cout gnd carry
vdd VDD gnd 1.8
va a gnd 0
va1 b gnd 0
va2 c gnd 1.8
**** begin user architecture code

.include carry_extracted_for_sim.spice
* carry_extracted.spice declares pin order (a GND VDD b cout cin), which does NOT
* match carry.sym's schematic pin order (VDD a b cin cout GND). Wrap it so the
* x1 instantiation below (generated from carry.sym) binds to the right nodes.
.subckt carry VDD a b cin cout GND
X0 a GND VDD b cout cin carry_layout
.ends

.control
* Walk a,b,cin through all 8 combinations (binary counter: cin fastest, a slowest)
alter @va[pulse]  = [ 0 1.8 0 10p 10p 4n 8n ]
alter @va1[pulse] = [ 0 1.8 0 10p 10p 2n 4n ]
alter @va2[pulse] = [ 0 1.8 0 10p 10p 1n 2n ]

* Run simulation
tran 1p 8n
* Sample cout at the center of each of the 8 settled windows
meas tran cout_000 FIND v(cout) AT=7.5n
meas tran cout_001 FIND v(cout) AT=6.5n
meas tran cout_010 FIND v(cout) AT=5.5n
meas tran cout_011 FIND v(cout) AT=4.5n
meas tran cout_100 FIND v(cout) AT=3.5n
meas tran cout_101 FIND v(cout) AT=2.5n
meas tran cout_110 FIND v(cout) AT=1.5n
meas tran cout_111 FIND v(cout) AT=0.5n
plot v(a) v(b) v(c) v(cout)
.endc

.lib /cad/share/pdk/sky130B/libs.tech/combined/sky130.lib.spice tt
**** end user architecture code
**.ends
.GLOBAL gnd
.GLOBAL VDD
.end
