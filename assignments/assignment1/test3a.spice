** stand-in for assign3a
.model nmos1 nmos level=1 vto=0.7 kp=100u
Vgs vin 0 dc 0 PULSE(0 1.8 0 10p 10p 1 1)
Vds vdd 0 1.8
C1 vout 0 100f
M1 vdd vin vout vout nmos1 W=0.42u L=0.15u
.include sim3a_test.cir
.end
