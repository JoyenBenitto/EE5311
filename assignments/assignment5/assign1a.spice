** sch_path: /home/joyen/ee5311/EE5311/assignments/assignment5/assign1a.sch
**.subckt assign1a
x1 VDD vin net1 VDD GND nand
x2 VDD net1 net2 VDD GND nand
V2 VDD GND 1.8
V1 vin GND PULSE 0 1.8 50p 5p 5p 400p 1n
**** begin user architecture code
.lib /cad/share/pdk/sky130B/libs.tech/combined/sky130.lib.spice tt

.control
tran 0.1p 1n
meas tran tphl trig v(vin) val=0.9 rise=1 targ v(net1) val=0.9 fall=1
meas tran tplh trig v(vin) val=0.9 fall=1 targ v(net1) val=0.9 rise=1
let tpd = (tphl + tplh) / 2
print tpd

plot v(net1) vin
.endc

**** end user architecture code
**.ends

* expanding   symbol:  nand.sym # of pins=5
** sym_path: /home/joyen/ee5311/EE5311/assignments/assignment5/nand.sym
** sch_path: /home/joyen/ee5311/EE5311/assignments/assignment5/nand.sch
.subckt nand VDD A out B GND
*.ipin A
*.opin out
*.iopin VDD
*.iopin GND
*.ipin B
XM1 out A net1 net2 sky130_fd_pr__nfet_01v8 L=0.15 W=1.68 nf=4 ad='int((nf+1)/2) * W/nf * 0.29' as='int((nf+2)/2) * W/nf * 0.29' pd='2*int((nf+1)/2) * (W/nf + 0.29)'
+ ps='2*int((nf+2)/2) * (W/nf + 0.29)' nrd='0.29 / W' nrs='0.29 / W' sa=0 sb=0 sd=0 mult=1
XM2 out A VDD net3 sky130_fd_pr__pfet_01v8 L=0.15 W=1.68 nf=4 ad='int((nf+1)/2) * W/nf * 0.29' as='int((nf+2)/2) * W/nf * 0.29' pd='2*int((nf+1)/2) * (W/nf + 0.29)'
+ ps='2*int((nf+2)/2) * (W/nf + 0.29)' nrd='0.29 / W' nrs='0.29 / W' sa=0 sb=0 sd=0 mult=1
XM3 net1 B GND net4 sky130_fd_pr__nfet_01v8 L=0.15 W=1.68 nf=4 ad='int((nf+1)/2) * W/nf * 0.29' as='int((nf+2)/2) * W/nf * 0.29' pd='2*int((nf+1)/2) * (W/nf + 0.29)'
+ ps='2*int((nf+2)/2) * (W/nf + 0.29)' nrd='0.29 / W' nrs='0.29 / W' sa=0 sb=0 sd=0 mult=1
XM4 out B VDD net5 sky130_fd_pr__pfet_01v8 L=0.15 W=1.68 nf=4 ad='int((nf+1)/2) * W/nf * 0.29' as='int((nf+2)/2) * W/nf * 0.29' pd='2*int((nf+1)/2) * (W/nf + 0.29)'
+ ps='2*int((nf+2)/2) * (W/nf + 0.29)' nrd='0.29 / W' nrs='0.29 / W' sa=0 sb=0 sd=0 mult=1
.ends

.GLOBAL VDD
.GLOBAL GND
.end
