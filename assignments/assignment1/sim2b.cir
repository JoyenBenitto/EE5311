.control

* Process / device parameters (pMOS, Tutorial 1)
let vt_p     = 0.7
let mu_p     = 0.009
let cox_p    = 8.16e-3
let vsat_p   = 3e4
let w_val    = 0.42u
let l_val    = 0.15u
let EsatL    = (vsat_p * l_val) / mu_p

* Vsg values to sweep, one named constant per index (mirrors sim1b.cir's
* Vgs1..4). Source/Body are tied to VDD, so the gate source "Vin" must be
* set to VDD - Vsg (an absolute node voltage), not Vsg directly.
let vsg1 = 0.6
let vsg2 = 1.0
let vsg3 = 1.4
let vsg4 = 1.8

foreach idx 1 2 3 4

  alter Vin = 1.8 - vsg$idx
  dc Vds 1.8 0 -0.02

  * Vds source sets the drain node's absolute voltage; Source/Body = VDD,
  * so Vsd = VDD - V(drain node). Sweeping the source from 1.8 down to 0
  * makes Vsd ascend from 0 to 1.8, same direction as sim1b.cir's Vds sweep.
  let vsd$idx      = 1.8 - v(vds)
  let isd_sim$idx  = i(Vds)
  let vsgt$idx     = max(0, vsg$idx - vt_p)
  let vsdsat$idx   = (vsgt$idx * EsatL) / (vsgt$idx + EsatL + 1e-12)
  let vmin$idx     = min(vsd$idx, vsdsat$idx)
  let isd_anal$idx = mu_p * cox_p * (w_val / l_val) * (vsgt$idx * vmin$idx - 0.5 * vmin$idx^2)
  let pct_error$idx = abs((isd_sim$idx - isd_anal$idx) / (isd_sim$idx + 1e-12)) * 100

  print mean(pct_error$idx)
end

* Human-readable aliases so the plot/hardcopy legend shows which curve is
* which Vsg, instead of the bare isd_simN/isd_analN/dcN.* vector names.
let Vsd_V            = dc1.vsd1
let Isd_sim_Vsg0_6V   = dc1.isd_sim1
let Isd_anal_Vsg0_6V  = dc1.isd_anal1
let Isd_sim_Vsg1_0V   = dc2.isd_sim2
let Isd_anal_Vsg1_0V  = dc2.isd_anal2
let Isd_sim_Vsg1_4V   = dc3.isd_sim3
let Isd_anal_Vsg1_4V  = dc3.isd_anal3
let Isd_sim_Vsg1_8V   = dc4.isd_sim4
let Isd_anal_Vsg1_8V  = dc4.isd_anal4

plot Isd_sim_Vsg0_6V Isd_anal_Vsg0_6V Isd_sim_Vsg1_0V Isd_anal_Vsg1_0V Isd_sim_Vsg1_4V Isd_anal_Vsg1_4V Isd_sim_Vsg1_8V Isd_anal_Vsg1_8V vs Vsd_V

hardcopy assign2b_output_char.ps Isd_sim_Vsg0_6V Isd_anal_Vsg0_6V Isd_sim_Vsg1_0V Isd_anal_Vsg1_0V Isd_sim_Vsg1_4V Isd_anal_Vsg1_4V Isd_sim_Vsg1_8V Isd_anal_Vsg1_8V vs Vsd_V

.endc
