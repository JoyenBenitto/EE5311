** sch_path: /home/joyen/ee5311/EE5311/assignments/assignment3/assign1a.sch
**.subckt assign1a
vin inp GND PULSE(0 1.8 0 5PS 5PS 50PS 300PS 5)
vin1 VDD GND 1.8
x1 net1 inp inverter
x2 out net1 inverter
C1 out net2 100f
**** begin user architecture code

.param width_p = 0.42

.control
* Run 1: Wp = 0.42
alterparam width_p = 0.42
reset
tran 0.1p 250p
let out_042 = v(out)
let in_042  = v(inp)
meas tran tlh_042 trig v(inp) val=0.9 rise=1 targ v(out) val=0.9 rise=1
meas tran thl_042 trig v(inp) val=0.9 fall=1 targ v(out) val=0.9 fall=1
let delay_042 = (tlh_042 + thl_042) / 2
echo Wp = 0.42 : delay = $&delay_042

* Run 2: Wp = 0.84
alterparam width_p = 0.84
reset
tran 0.1p 250p
let out_084 = v(out)
let in_084  = v(inp)
meas tran tlh_084 trig v(inp) val=0.9 rise=1 targ v(out) val=0.9 rise=1
meas tran thl_084 trig v(inp) val=0.9 fall=1 targ v(out) val=0.9 fall=1
let delay_084 = (tlh_084 + thl_084) / 2
echo Wp = 0.84 : delay = $&delay_084

* Run 3: Wp = 1.26
alterparam width_p = 1.26
reset
tran 0.1p 250p
let out_126 = v(out)
let in_126  = v(inp)
meas tran tlh_126 trig v(inp) val=0.9 rise=1 targ v(out) val=0.9 rise=1
meas tran thl_126 trig v(inp) val=0.9 fall=1 targ v(out) val=0.9 fall=1
let delay_126 = (tlh_126 + thl_126) / 2
echo Wp = 1.26 : delay = $&delay_126

* Overlay all three runs on one plot, each curve tagged by its Wp
plot tran1.out_042 tran2.out_084 tran3.out_126 tran1.in_042 xlabel Time ylabel Voltage title 'v(out) for Wp = 0.42 / 0.84 / 1.26'
.endc

.lib /cad/share/pdk/sky130B/libs.tech/combined/sky130.lib.spice tt
**** end user architecture code
**.ends

* expanding   symbol:  inverter.sym # of pins=2
** sym_path: /home/joyen/ee5311/EE5311/assignments/assignment3/inverter.sym
** sch_path: /home/joyen/ee5311/EE5311/assignments/assignment3/inverter.sch
.subckt inverter y a
*.ipin a
*.opin y
XM1 y a GND GND sky130_fd_pr__nfet_01v8 L=0.15 W=0.42 nf=1 ad='int((nf+1)/2) * W/nf * 0.29' as='int((nf+2)/2) * W/nf * 0.29' pd='2*int((nf+1)/2) * (W/nf + 0.29)'
+ ps='2*int((nf+2)/2) * (W/nf + 0.29)' nrd='0.29 / W' nrs='0.29 / W' sa=0 sb=0 sd=0 mult=1
XM2 y a VDD VDD sky130_fd_pr__pfet_01v8 L=0.15 W={width_p} nf=1 ad='int((nf+1)/2) * W/nf * 0.29' as='int((nf+2)/2) * W/nf * 0.29' pd='2*int((nf+1)/2) * (W/nf + 0.29)'
+ ps='2*int((nf+2)/2) * (W/nf + 0.29)' nrd='0.29 / W' nrs='0.29 / W' sa=0 sb=0 sd=0 mult=1
.ends

.GLOBAL GND
.GLOBAL VDD
.end
