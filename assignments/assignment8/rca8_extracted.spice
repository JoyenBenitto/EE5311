* NGSPICE file created from rca8.ext - technology: sky130A

.subckt rca8 cout7 cin0 b2 a2 b3 a3 b4 a4 b5 a5 b6 a6 b7 a7 b0 a0 b1 a1 sout0 sout1
+ sout2 sout3 sout4 sout5 sout6 sout7 GND VDD
X0 GND b6 a_n1027_4456# GND sky130_fd_pr__nfet_01v8 ad=0.105 pd=0.92 as=0.126 ps=1.44 w=0.42 l=0.15
X1 VDD a1 a_n1730_850# VDD sky130_fd_pr__pfet_01v8 ad=0.252 pd=2.28 as=0.21 ps=1.34 w=0.84 l=0.15
X2 VDD a5 a_n1730_3996# VDD sky130_fd_pr__pfet_01v8 ad=0.252 pd=2.28 as=0.21 ps=1.34 w=0.84 l=0.15
X3 GND a6 a_n3317_4511# GND sky130_fd_pr__nfet_01v8 ad=0.126 pd=1.44 as=0.105 ps=0.92 w=0.42 l=0.15
X4 a_n2911_2155# b3 GND GND sky130_fd_pr__nfet_01v8 ad=0.105 pd=0.92 as=0.105 ps=0.92 w=0.42 l=0.15
X5 GND a1 a_n1027_522# GND sky130_fd_pr__nfet_01v8 ad=0.105 pd=0.92 as=0.105 ps=0.92 w=0.42 l=0.15
X6 GND a1 a_n1749_522# GND sky130_fd_pr__nfet_01v8 ad=0.126 pd=1.44 as=0.105 ps=0.92 w=0.42 l=0.15
X7 GND a1 a_n2911_578# GND sky130_fd_pr__nfet_01v8 ad=0.105 pd=0.92 as=0.105 ps=0.92 w=0.42 l=0.15
X8 a_n3317_929# b1 a_n3447_929# VDD sky130_fd_pr__pfet_01v8 ad=0.105 pd=0.92 as=0.105 ps=0.92 w=0.42 l=0.15
X9 VDD a6 a_n3317_4863# VDD sky130_fd_pr__pfet_01v8 ad=0.126 pd=1.44 as=0.105 ps=0.92 w=0.42 l=0.15
X10 GND a4 a_n2911_2909# GND sky130_fd_pr__nfet_01v8 ad=0.105 pd=0.92 as=0.105 ps=0.92 w=0.42 l=0.15
X11 a_n1749_1311# b2 a_n3634_2342# GND sky130_fd_pr__nfet_01v8 ad=0.126 pd=1.44 as=0.105 ps=0.92 w=0.42 l=0.15
X12 GND a_n3634_4699# a_n2911_4512# GND sky130_fd_pr__nfet_01v8 ad=0.126 pd=1.44 as=0.105 ps=0.92 w=0.42 l=0.15
X13 VDD a5 a_n2911_4075# VDD sky130_fd_pr__pfet_01v8 ad=0.105 pd=0.92 as=0.105 ps=0.92 w=0.42 l=0.15
X14 a_n3634_1554# b1 a_n1730_850# VDD sky130_fd_pr__pfet_01v8 ad=0.21 pd=1.34 as=0.252 ps=2.28 w=0.84 l=0.15
X15 cout7 b7 a_n1730_5538# VDD sky130_fd_pr__pfet_01v8 ad=0.21 pd=1.34 as=0.252 ps=2.28 w=0.84 l=0.15
X16 a_n1027_5210# a_n3634_5453# cout7 GND sky130_fd_pr__nfet_01v8 ad=0.126 pd=1.44 as=0.105 ps=0.92 w=0.42 l=0.15
X17 a_n3634_3096# b3 a_n1749_2099# GND sky130_fd_pr__nfet_01v8 ad=0.105 pd=0.92 as=0.126 ps=1.44 w=0.42 l=0.15
X18 a_n2911_4863# a_n3634_5453# sout6 VDD sky130_fd_pr__pfet_01v8 ad=0.105 pd=0.92 as=0.126 ps=1.44 w=0.42 l=0.15
X19 VDD a3 a_n2911_2506# VDD sky130_fd_pr__pfet_01v8 ad=0.105 pd=0.92 as=0.105 ps=0.92 w=0.42 l=0.15
X20 a_n1008_1639# b2 VDD VDD sky130_fd_pr__pfet_01v8 ad=0.21 pd=1.34 as=0.21 ps=1.34 w=0.84 l=0.15
X21 a_n2911_5617# b7 VDD VDD sky130_fd_pr__pfet_01v8 ad=0.105 pd=0.92 as=0.105 ps=0.92 w=0.42 l=0.15
X22 a_n1730_4784# a6 VDD VDD sky130_fd_pr__pfet_01v8 ad=0.21 pd=1.34 as=0.252 ps=2.28 w=0.84 l=0.15
X23 VDD b5 a_n1008_3996# VDD sky130_fd_pr__pfet_01v8 ad=0.21 pd=1.34 as=0.252 ps=2.28 w=0.84 l=0.15
X24 VDD a4 a_n2911_3260# VDD sky130_fd_pr__pfet_01v8 ad=0.105 pd=0.92 as=0.105 ps=0.92 w=0.42 l=0.15
X25 VDD a3 a_n1730_2427# VDD sky130_fd_pr__pfet_01v8 ad=0.252 pd=2.28 as=0.21 ps=1.34 w=0.84 l=0.15
X26 a_n1027_3668# a_n3634_3911# a_n3634_4699# GND sky130_fd_pr__nfet_01v8 ad=0.126 pd=1.44 as=0.105 ps=0.92 w=0.42 l=0.15
X27 VDD a4 a_n1730_3181# VDD sky130_fd_pr__pfet_01v8 ad=0.252 pd=2.28 as=0.21 ps=1.34 w=0.84 l=0.15
X28 a_n1027_522# a1 GND GND sky130_fd_pr__nfet_01v8 ad=0.126 pd=1.44 as=0.105 ps=0.92 w=0.42 l=0.15
X29 a_n3634_1554# b1 a_n1749_522# GND sky130_fd_pr__nfet_01v8 ad=0.105 pd=0.92 as=0.126 ps=1.44 w=0.42 l=0.15
X30 a_n1027_1311# b2 GND GND sky130_fd_pr__nfet_01v8 ad=0.105 pd=0.92 as=0.105 ps=0.92 w=0.42 l=0.15
X31 VDD a1 a_n3317_929# VDD sky130_fd_pr__pfet_01v8 ad=0.126 pd=1.44 as=0.105 ps=0.92 w=0.42 l=0.15
X32 a_n2911_5266# cout7 sout7 GND sky130_fd_pr__nfet_01v8 ad=0.105 pd=0.92 as=0.126 ps=1.44 w=0.42 l=0.15
X33 a_n1749_4456# b6 a_n3634_5453# GND sky130_fd_pr__nfet_01v8 ad=0.126 pd=1.44 as=0.105 ps=0.92 w=0.42 l=0.15
X34 GND b3 a_n1027_2099# GND sky130_fd_pr__nfet_01v8 ad=0.105 pd=0.92 as=0.126 ps=1.44 w=0.42 l=0.15
X35 a_n3447_141# cin0 sout0 VDD sky130_fd_pr__pfet_01v8 ad=0.105 pd=0.92 as=0.126 ps=1.44 w=0.42 l=0.15
X36 a_n3634_2342# a_n3634_1554# a_n1027_1311# GND sky130_fd_pr__nfet_01v8 ad=0.105 pd=0.92 as=0.126 ps=1.44 w=0.42 l=0.15
X37 a_n1027_2853# a_n3634_3096# a_n3634_3911# GND sky130_fd_pr__nfet_01v8 ad=0.126 pd=1.44 as=0.105 ps=0.92 w=0.42 l=0.15
X38 GND a3 a_n3317_2154# GND sky130_fd_pr__nfet_01v8 ad=0.126 pd=1.44 as=0.105 ps=0.92 w=0.42 l=0.15
X39 a_n1730_850# b1 a_n3634_1554# VDD sky130_fd_pr__pfet_01v8 ad=0.252 pd=2.28 as=0.21 ps=1.34 w=0.84 l=0.15
X40 a_n1027_4456# b6 GND GND sky130_fd_pr__nfet_01v8 ad=0.105 pd=0.92 as=0.105 ps=0.92 w=0.42 l=0.15
X41 VDD b3 a_n1008_2427# VDD sky130_fd_pr__pfet_01v8 ad=0.21 pd=1.34 as=0.252 ps=2.28 w=0.84 l=0.15
X42 GND b1 a_n1027_522# GND sky130_fd_pr__nfet_01v8 ad=0.105 pd=0.92 as=0.126 ps=1.44 w=0.42 l=0.15
X43 a_n1749_522# b1 a_n3634_1554# GND sky130_fd_pr__nfet_01v8 ad=0.126 pd=1.44 as=0.105 ps=0.92 w=0.42 l=0.15
X44 a_n3634_5453# a_n3634_4699# a_n1027_4456# GND sky130_fd_pr__nfet_01v8 ad=0.105 pd=0.92 as=0.126 ps=1.44 w=0.42 l=0.15
X45 VDD b4 a_n1008_3181# VDD sky130_fd_pr__pfet_01v8 ad=0.21 pd=1.34 as=0.252 ps=2.28 w=0.84 l=0.15
X46 GND a_n3634_2342# a_n2911_2155# GND sky130_fd_pr__nfet_01v8 ad=0.126 pd=1.44 as=0.105 ps=0.92 w=0.42 l=0.15
X47 VDD a0 a_n1730_62# VDD sky130_fd_pr__pfet_01v8 ad=0.252 pd=2.28 as=0.21 ps=1.34 w=0.84 l=0.15
X48 a_n3317_141# b0 a_n3447_141# VDD sky130_fd_pr__pfet_01v8 ad=0.105 pd=0.92 as=0.105 ps=0.92 w=0.42 l=0.15
X49 a_n2911_3724# a_n3634_4699# sout5 GND sky130_fd_pr__nfet_01v8 ad=0.105 pd=0.92 as=0.126 ps=1.44 w=0.42 l=0.15
X50 a_n3634_765# b0 a_n1749_n266# GND sky130_fd_pr__nfet_01v8 ad=0.105 pd=0.92 as=0.126 ps=1.44 w=0.42 l=0.15
X51 VDD b0 a_n1008_62# VDD sky130_fd_pr__pfet_01v8 ad=0.21 pd=1.34 as=0.252 ps=2.28 w=0.84 l=0.15
X52 a_n3447_577# a_n3634_765# sout1 GND sky130_fd_pr__nfet_01v8 ad=0.105 pd=0.92 as=0.126 ps=1.44 w=0.42 l=0.15
X53 a_n1730_5538# b7 cout7 VDD sky130_fd_pr__pfet_01v8 ad=0.252 pd=2.28 as=0.21 ps=1.34 w=0.84 l=0.15
X54 a_n1749_2099# b3 a_n3634_3096# GND sky130_fd_pr__nfet_01v8 ad=0.126 pd=1.44 as=0.105 ps=0.92 w=0.42 l=0.15
X55 VDD a6 a_n2911_4863# VDD sky130_fd_pr__pfet_01v8 ad=0.105 pd=0.92 as=0.105 ps=0.92 w=0.42 l=0.15
X56 a_n1027_522# b1 GND GND sky130_fd_pr__nfet_01v8 ad=0.105 pd=0.92 as=0.105 ps=0.92 w=0.42 l=0.15
X57 VDD a_n3634_5453# a_n2911_5617# VDD sky130_fd_pr__pfet_01v8 ad=0.126 pd=1.44 as=0.105 ps=0.92 w=0.42 l=0.15
X58 VDD a6 a_n1730_4784# VDD sky130_fd_pr__pfet_01v8 ad=0.252 pd=2.28 as=0.21 ps=1.34 w=0.84 l=0.15
X59 a_n1008_3996# b5 VDD VDD sky130_fd_pr__pfet_01v8 ad=0.21 pd=1.34 as=0.21 ps=1.34 w=0.84 l=0.15
X60 a_n1749_5210# a7 GND GND sky130_fd_pr__nfet_01v8 ad=0.105 pd=0.92 as=0.126 ps=1.44 w=0.42 l=0.15
X61 GND b0 a_n1027_n266# GND sky130_fd_pr__nfet_01v8 ad=0.105 pd=0.92 as=0.126 ps=1.44 w=0.42 l=0.15
X62 a_n3447_5617# a_n3634_5453# sout7 VDD sky130_fd_pr__pfet_01v8 ad=0.105 pd=0.92 as=0.126 ps=1.44 w=0.42 l=0.15
X63 VDD a0 a_n3317_141# VDD sky130_fd_pr__pfet_01v8 ad=0.126 pd=1.44 as=0.105 ps=0.92 w=0.42 l=0.15
X64 a_n3634_2342# b2 a_n1730_1639# VDD sky130_fd_pr__pfet_01v8 ad=0.21 pd=1.34 as=0.252 ps=2.28 w=0.84 l=0.15
X65 GND a7 a_n2911_5266# GND sky130_fd_pr__nfet_01v8 ad=0.105 pd=0.92 as=0.105 ps=0.92 w=0.42 l=0.15
X66 a_n1027_2099# b3 GND GND sky130_fd_pr__nfet_01v8 ad=0.105 pd=0.92 as=0.105 ps=0.92 w=0.42 l=0.15
X67 a_n2911_n210# a_n3634_765# sout0 GND sky130_fd_pr__nfet_01v8 ad=0.105 pd=0.92 as=0.126 ps=1.44 w=0.42 l=0.15
X68 a_n3317_577# b1 a_n3447_577# GND sky130_fd_pr__nfet_01v8 ad=0.105 pd=0.92 as=0.105 ps=0.92 w=0.42 l=0.15
X69 a_n1027_1311# a_n3634_1554# a_n3634_2342# GND sky130_fd_pr__nfet_01v8 ad=0.126 pd=1.44 as=0.105 ps=0.92 w=0.42 l=0.15
X70 cout7 a_n3634_5453# a_n1008_5538# VDD sky130_fd_pr__pfet_01v8 ad=0.21 pd=1.34 as=0.252 ps=2.28 w=0.84 l=0.15
X71 a_n1749_3668# a5 GND GND sky130_fd_pr__nfet_01v8 ad=0.105 pd=0.92 as=0.126 ps=1.44 w=0.42 l=0.15
X72 a_n3634_3096# a_n3634_2342# a_n1027_2099# GND sky130_fd_pr__nfet_01v8 ad=0.105 pd=0.92 as=0.126 ps=1.44 w=0.42 l=0.15
X73 a_n2911_1718# b2 VDD VDD sky130_fd_pr__pfet_01v8 ad=0.105 pd=0.92 as=0.105 ps=0.92 w=0.42 l=0.15
X74 a_n3447_2908# a_n3634_3096# sout4 GND sky130_fd_pr__nfet_01v8 ad=0.105 pd=0.92 as=0.126 ps=1.44 w=0.42 l=0.15
X75 a_n1749_2853# a4 GND GND sky130_fd_pr__nfet_01v8 ad=0.105 pd=0.92 as=0.126 ps=1.44 w=0.42 l=0.15
X76 a_n2911_1367# a_n3634_2342# sout2 GND sky130_fd_pr__nfet_01v8 ad=0.105 pd=0.92 as=0.126 ps=1.44 w=0.42 l=0.15
X77 VDD b6 a_n1008_4784# VDD sky130_fd_pr__pfet_01v8 ad=0.21 pd=1.34 as=0.252 ps=2.28 w=0.84 l=0.15
X78 a_n1008_2427# b3 VDD VDD sky130_fd_pr__pfet_01v8 ad=0.21 pd=1.34 as=0.21 ps=1.34 w=0.84 l=0.15
X79 a_n2911_929# b1 VDD VDD sky130_fd_pr__pfet_01v8 ad=0.105 pd=0.92 as=0.105 ps=0.92 w=0.42 l=0.15
X80 VDD a7 a_n1008_5538# VDD sky130_fd_pr__pfet_01v8 ad=0.21 pd=1.34 as=0.21 ps=1.34 w=0.84 l=0.15
X81 a_n1027_4456# a_n3634_4699# a_n3634_5453# GND sky130_fd_pr__nfet_01v8 ad=0.126 pd=1.44 as=0.105 ps=0.92 w=0.42 l=0.15
X82 a_n1008_3181# b4 VDD VDD sky130_fd_pr__pfet_01v8 ad=0.21 pd=1.34 as=0.21 ps=1.34 w=0.84 l=0.15
X83 VDD a1 a_n1008_850# VDD sky130_fd_pr__pfet_01v8 ad=0.21 pd=1.34 as=0.21 ps=1.34 w=0.84 l=0.15
X84 a_n3634_1554# a_n3634_765# a_n1008_850# VDD sky130_fd_pr__pfet_01v8 ad=0.21 pd=1.34 as=0.252 ps=2.28 w=0.84 l=0.15
X85 GND a7 a_n1027_5210# GND sky130_fd_pr__nfet_01v8 ad=0.105 pd=0.92 as=0.105 ps=0.92 w=0.42 l=0.15
X86 GND a5 a_n2911_3724# GND sky130_fd_pr__nfet_01v8 ad=0.105 pd=0.92 as=0.105 ps=0.92 w=0.42 l=0.15
X87 GND a1 a_n3317_577# GND sky130_fd_pr__nfet_01v8 ad=0.126 pd=1.44 as=0.105 ps=0.92 w=0.42 l=0.15
X88 a_n1749_n266# b0 a_n3634_765# GND sky130_fd_pr__nfet_01v8 ad=0.126 pd=1.44 as=0.105 ps=0.92 w=0.42 l=0.15
X89 GND a5 a_n1027_3668# GND sky130_fd_pr__nfet_01v8 ad=0.105 pd=0.92 as=0.105 ps=0.92 w=0.42 l=0.15
X90 a_n3634_1554# a_n3634_765# a_n1027_522# GND sky130_fd_pr__nfet_01v8 ad=0.105 pd=0.92 as=0.126 ps=1.44 w=0.42 l=0.15
X91 VDD a_n3634_765# a_n2911_929# VDD sky130_fd_pr__pfet_01v8 ad=0.126 pd=1.44 as=0.105 ps=0.92 w=0.42 l=0.15
X92 GND a4 a_n1027_2853# GND sky130_fd_pr__nfet_01v8 ad=0.105 pd=0.92 as=0.105 ps=0.92 w=0.42 l=0.15
X93 a_n1008_850# a1 VDD VDD sky130_fd_pr__pfet_01v8 ad=0.252 pd=2.28 as=0.21 ps=1.34 w=0.84 l=0.15
X94 a_n1008_850# a_n3634_765# a_n3634_1554# VDD sky130_fd_pr__pfet_01v8 ad=0.252 pd=2.28 as=0.21 ps=1.34 w=0.84 l=0.15
X95 GND a7 a_n1749_5210# GND sky130_fd_pr__nfet_01v8 ad=0.126 pd=1.44 as=0.105 ps=0.92 w=0.42 l=0.15
X96 a_n1027_n266# b0 GND GND sky130_fd_pr__nfet_01v8 ad=0.105 pd=0.92 as=0.105 ps=0.92 w=0.42 l=0.15
X97 a_n3317_5617# b7 a_n3447_5617# VDD sky130_fd_pr__pfet_01v8 ad=0.105 pd=0.92 as=0.105 ps=0.92 w=0.42 l=0.15
X98 a_n3634_4699# b5 a_n1730_3996# VDD sky130_fd_pr__pfet_01v8 ad=0.21 pd=1.34 as=0.252 ps=2.28 w=0.84 l=0.15
X99 a_n3634_765# cin0 a_n1027_n266# GND sky130_fd_pr__nfet_01v8 ad=0.105 pd=0.92 as=0.126 ps=1.44 w=0.42 l=0.15
X100 a_n1730_1639# b2 a_n3634_2342# VDD sky130_fd_pr__pfet_01v8 ad=0.252 pd=2.28 as=0.21 ps=1.34 w=0.84 l=0.15
X101 a_n2911_4512# a_n3634_5453# sout6 GND sky130_fd_pr__nfet_01v8 ad=0.105 pd=0.92 as=0.126 ps=1.44 w=0.42 l=0.15
X102 GND a0 a_n2911_n210# GND sky130_fd_pr__nfet_01v8 ad=0.105 pd=0.92 as=0.105 ps=0.92 w=0.42 l=0.15
X103 a_n1008_62# a0 VDD VDD sky130_fd_pr__pfet_01v8 ad=0.252 pd=2.28 as=0.21 ps=1.34 w=0.84 l=0.15
X104 a_n1008_5538# a_n3634_5453# cout7 VDD sky130_fd_pr__pfet_01v8 ad=0.252 pd=2.28 as=0.21 ps=1.34 w=0.84 l=0.15
X105 GND a5 a_n1749_3668# GND sky130_fd_pr__nfet_01v8 ad=0.126 pd=1.44 as=0.105 ps=0.92 w=0.42 l=0.15
X106 a_n1027_2099# a_n3634_2342# a_n3634_3096# GND sky130_fd_pr__nfet_01v8 ad=0.126 pd=1.44 as=0.105 ps=0.92 w=0.42 l=0.15
X107 a_n1730_62# b0 a_n3634_765# VDD sky130_fd_pr__pfet_01v8 ad=0.252 pd=2.28 as=0.21 ps=1.34 w=0.84 l=0.15
X108 a_n1027_522# a_n3634_765# a_n3634_1554# GND sky130_fd_pr__nfet_01v8 ad=0.126 pd=1.44 as=0.105 ps=0.92 w=0.42 l=0.15
X109 VDD a_n3634_1554# a_n2911_1718# VDD sky130_fd_pr__pfet_01v8 ad=0.126 pd=1.44 as=0.105 ps=0.92 w=0.42 l=0.15
X110 a_n3317_2908# b4 a_n3447_2908# GND sky130_fd_pr__nfet_01v8 ad=0.105 pd=0.92 as=0.105 ps=0.92 w=0.42 l=0.15
X111 a_n1749_1311# a2 GND GND sky130_fd_pr__nfet_01v8 ad=0.105 pd=0.92 as=0.126 ps=1.44 w=0.42 l=0.15
X112 a_n3447_1718# a_n3634_1554# sout2 VDD sky130_fd_pr__pfet_01v8 ad=0.105 pd=0.92 as=0.126 ps=1.44 w=0.42 l=0.15
X113 a_n2911_929# a_n3634_1554# sout1 VDD sky130_fd_pr__pfet_01v8 ad=0.105 pd=0.92 as=0.126 ps=1.44 w=0.42 l=0.15
X114 GND a4 a_n1749_2853# GND sky130_fd_pr__nfet_01v8 ad=0.126 pd=1.44 as=0.105 ps=0.92 w=0.42 l=0.15
X115 GND a2 a_n2911_1367# GND sky130_fd_pr__nfet_01v8 ad=0.105 pd=0.92 as=0.105 ps=0.92 w=0.42 l=0.15
X116 a_n1008_4784# b6 VDD VDD sky130_fd_pr__pfet_01v8 ad=0.21 pd=1.34 as=0.21 ps=1.34 w=0.84 l=0.15
X117 a_n2911_141# b0 VDD VDD sky130_fd_pr__pfet_01v8 ad=0.105 pd=0.92 as=0.105 ps=0.92 w=0.42 l=0.15
X118 VDD b1 a_n1008_850# VDD sky130_fd_pr__pfet_01v8 ad=0.21 pd=1.34 as=0.252 ps=2.28 w=0.84 l=0.15
X119 a_n3634_2342# a_n3634_1554# a_n1008_1639# VDD sky130_fd_pr__pfet_01v8 ad=0.21 pd=1.34 as=0.252 ps=2.28 w=0.84 l=0.15
X120 a_n1008_5538# a7 VDD VDD sky130_fd_pr__pfet_01v8 ad=0.252 pd=2.28 as=0.21 ps=1.34 w=0.84 l=0.15
X121 a_n1730_62# a0 VDD VDD sky130_fd_pr__pfet_01v8 ad=0.21 pd=1.34 as=0.252 ps=2.28 w=0.84 l=0.15
X122 a_n2911_2909# b4 GND GND sky130_fd_pr__nfet_01v8 ad=0.105 pd=0.92 as=0.105 ps=0.92 w=0.42 l=0.15
X123 a_n1027_5210# a7 GND GND sky130_fd_pr__nfet_01v8 ad=0.126 pd=1.44 as=0.105 ps=0.92 w=0.42 l=0.15
X124 a_n2911_4075# b5 VDD VDD sky130_fd_pr__pfet_01v8 ad=0.105 pd=0.92 as=0.105 ps=0.92 w=0.42 l=0.15
X125 a_n3634_3096# b3 a_n1730_2427# VDD sky130_fd_pr__pfet_01v8 ad=0.21 pd=1.34 as=0.252 ps=2.28 w=0.84 l=0.15
X126 a_n3447_5265# a_n3634_5453# sout7 GND sky130_fd_pr__nfet_01v8 ad=0.105 pd=0.92 as=0.126 ps=1.44 w=0.42 l=0.15
X127 a_n1749_4456# a6 GND GND sky130_fd_pr__nfet_01v8 ad=0.105 pd=0.92 as=0.126 ps=1.44 w=0.42 l=0.15
X128 a_n3634_3911# b4 a_n1730_3181# VDD sky130_fd_pr__pfet_01v8 ad=0.21 pd=1.34 as=0.252 ps=2.28 w=0.84 l=0.15
X129 a_n2911_2506# b3 VDD VDD sky130_fd_pr__pfet_01v8 ad=0.105 pd=0.92 as=0.105 ps=0.92 w=0.42 l=0.15
X130 VDD a2 a_n1008_1639# VDD sky130_fd_pr__pfet_01v8 ad=0.21 pd=1.34 as=0.21 ps=1.34 w=0.84 l=0.15
X131 a_n1027_3668# a5 GND GND sky130_fd_pr__nfet_01v8 ad=0.126 pd=1.44 as=0.105 ps=0.92 w=0.42 l=0.15
X132 a_n2911_3260# b4 VDD VDD sky130_fd_pr__pfet_01v8 ad=0.105 pd=0.92 as=0.105 ps=0.92 w=0.42 l=0.15
X133 VDD a1 a_n2911_929# VDD sky130_fd_pr__pfet_01v8 ad=0.105 pd=0.92 as=0.105 ps=0.92 w=0.42 l=0.15
X134 a_n2911_2155# a_n3634_3096# sout3 GND sky130_fd_pr__nfet_01v8 ad=0.105 pd=0.92 as=0.126 ps=1.44 w=0.42 l=0.15
X135 VDD cin0 a_n2911_141# VDD sky130_fd_pr__pfet_01v8 ad=0.126 pd=1.44 as=0.105 ps=0.92 w=0.42 l=0.15
X136 GND a2 a_n1027_1311# GND sky130_fd_pr__nfet_01v8 ad=0.105 pd=0.92 as=0.105 ps=0.92 w=0.42 l=0.15
X137 a_n1027_2853# a4 GND GND sky130_fd_pr__nfet_01v8 ad=0.126 pd=1.44 as=0.105 ps=0.92 w=0.42 l=0.15
X138 a_n1008_850# b1 VDD VDD sky130_fd_pr__pfet_01v8 ad=0.21 pd=1.34 as=0.21 ps=1.34 w=0.84 l=0.15
X139 VDD a7 a_n3317_5617# VDD sky130_fd_pr__pfet_01v8 ad=0.126 pd=1.44 as=0.105 ps=0.92 w=0.42 l=0.15
X140 a_n1730_3996# b5 a_n3634_4699# VDD sky130_fd_pr__pfet_01v8 ad=0.252 pd=2.28 as=0.21 ps=1.34 w=0.84 l=0.15
X141 a_n1027_n266# cin0 a_n3634_765# GND sky130_fd_pr__nfet_01v8 ad=0.126 pd=1.44 as=0.105 ps=0.92 w=0.42 l=0.15
X142 GND a6 a_n2911_4512# GND sky130_fd_pr__nfet_01v8 ad=0.105 pd=0.92 as=0.105 ps=0.92 w=0.42 l=0.15
X143 a_n3447_3723# a_n3634_3911# sout5 GND sky130_fd_pr__nfet_01v8 ad=0.105 pd=0.92 as=0.126 ps=1.44 w=0.42 l=0.15
X144 GND a6 a_n1027_4456# GND sky130_fd_pr__nfet_01v8 ad=0.105 pd=0.92 as=0.105 ps=0.92 w=0.42 l=0.15
X145 GND a4 a_n3317_2908# GND sky130_fd_pr__nfet_01v8 ad=0.126 pd=1.44 as=0.105 ps=0.92 w=0.42 l=0.15
X146 GND a2 a_n1749_1311# GND sky130_fd_pr__nfet_01v8 ad=0.126 pd=1.44 as=0.105 ps=0.92 w=0.42 l=0.15
X147 a_n2911_5617# cout7 sout7 VDD sky130_fd_pr__pfet_01v8 ad=0.105 pd=0.92 as=0.126 ps=1.44 w=0.42 l=0.15
X148 a_n3317_1718# b2 a_n3447_1718# VDD sky130_fd_pr__pfet_01v8 ad=0.105 pd=0.92 as=0.105 ps=0.92 w=0.42 l=0.15
X149 a_n2911_141# a_n3634_765# sout0 VDD sky130_fd_pr__pfet_01v8 ad=0.105 pd=0.92 as=0.126 ps=1.44 w=0.42 l=0.15
X150 a_n1730_5538# a7 VDD VDD sky130_fd_pr__pfet_01v8 ad=0.21 pd=1.34 as=0.252 ps=2.28 w=0.84 l=0.15
X151 a_n1749_2099# a3 GND GND sky130_fd_pr__nfet_01v8 ad=0.105 pd=0.92 as=0.126 ps=1.44 w=0.42 l=0.15
X152 a_n1008_1639# a_n3634_1554# a_n3634_2342# VDD sky130_fd_pr__pfet_01v8 ad=0.252 pd=2.28 as=0.21 ps=1.34 w=0.84 l=0.15
X153 a_n3634_4699# a_n3634_3911# a_n1008_3996# VDD sky130_fd_pr__pfet_01v8 ad=0.21 pd=1.34 as=0.252 ps=2.28 w=0.84 l=0.15
X154 a_n3447_n211# cin0 sout0 GND sky130_fd_pr__nfet_01v8 ad=0.105 pd=0.92 as=0.126 ps=1.44 w=0.42 l=0.15
X155 GND a_n3634_3096# a_n2911_2909# GND sky130_fd_pr__nfet_01v8 ad=0.126 pd=1.44 as=0.105 ps=0.92 w=0.42 l=0.15
X156 a_n3634_5453# b6 a_n1730_4784# VDD sky130_fd_pr__pfet_01v8 ad=0.21 pd=1.34 as=0.252 ps=2.28 w=0.84 l=0.15
X157 VDD a_n3634_3911# a_n2911_4075# VDD sky130_fd_pr__pfet_01v8 ad=0.126 pd=1.44 as=0.105 ps=0.92 w=0.42 l=0.15
X158 a_n1730_2427# b3 a_n3634_3096# VDD sky130_fd_pr__pfet_01v8 ad=0.252 pd=2.28 as=0.21 ps=1.34 w=0.84 l=0.15
X159 a_n3317_5265# b7 a_n3447_5265# GND sky130_fd_pr__nfet_01v8 ad=0.105 pd=0.92 as=0.105 ps=0.92 w=0.42 l=0.15
X160 GND a6 a_n1749_4456# GND sky130_fd_pr__nfet_01v8 ad=0.126 pd=1.44 as=0.105 ps=0.92 w=0.42 l=0.15
X161 a_n1730_3181# b4 a_n3634_3911# VDD sky130_fd_pr__pfet_01v8 ad=0.252 pd=2.28 as=0.21 ps=1.34 w=0.84 l=0.15
X162 a_n2911_4863# b6 VDD VDD sky130_fd_pr__pfet_01v8 ad=0.105 pd=0.92 as=0.105 ps=0.92 w=0.42 l=0.15
X163 a_n3447_4075# a_n3634_3911# sout5 VDD sky130_fd_pr__pfet_01v8 ad=0.105 pd=0.92 as=0.126 ps=1.44 w=0.42 l=0.15
X164 VDD a_n3634_2342# a_n2911_2506# VDD sky130_fd_pr__pfet_01v8 ad=0.126 pd=1.44 as=0.105 ps=0.92 w=0.42 l=0.15
X165 a_n1008_1639# a2 VDD VDD sky130_fd_pr__pfet_01v8 ad=0.252 pd=2.28 as=0.21 ps=1.34 w=0.84 l=0.15
X166 VDD a5 a_n1008_3996# VDD sky130_fd_pr__pfet_01v8 ad=0.21 pd=1.34 as=0.21 ps=1.34 w=0.84 l=0.15
X167 VDD a_n3634_3096# a_n2911_3260# VDD sky130_fd_pr__pfet_01v8 ad=0.126 pd=1.44 as=0.105 ps=0.92 w=0.42 l=0.15
X168 VDD a0 a_n2911_141# VDD sky130_fd_pr__pfet_01v8 ad=0.105 pd=0.92 as=0.105 ps=0.92 w=0.42 l=0.15
X169 a_n3447_2506# a_n3634_2342# sout3 VDD sky130_fd_pr__pfet_01v8 ad=0.105 pd=0.92 as=0.126 ps=1.44 w=0.42 l=0.15
X170 GND a3 a_n2911_2155# GND sky130_fd_pr__nfet_01v8 ad=0.105 pd=0.92 as=0.105 ps=0.92 w=0.42 l=0.15
X171 a_n1027_1311# a2 GND GND sky130_fd_pr__nfet_01v8 ad=0.126 pd=1.44 as=0.105 ps=0.92 w=0.42 l=0.15
X172 a_n3447_1366# a_n3634_1554# sout2 GND sky130_fd_pr__nfet_01v8 ad=0.105 pd=0.92 as=0.126 ps=1.44 w=0.42 l=0.15
X173 a_n2911_5266# b7 GND GND sky130_fd_pr__nfet_01v8 ad=0.105 pd=0.92 as=0.105 ps=0.92 w=0.42 l=0.15
X174 a_n3447_3260# a_n3634_3096# sout4 VDD sky130_fd_pr__pfet_01v8 ad=0.105 pd=0.92 as=0.126 ps=1.44 w=0.42 l=0.15
X175 a_n3634_3096# a_n3634_2342# a_n1008_2427# VDD sky130_fd_pr__pfet_01v8 ad=0.21 pd=1.34 as=0.252 ps=2.28 w=0.84 l=0.15
X176 GND a3 a_n1027_2099# GND sky130_fd_pr__nfet_01v8 ad=0.105 pd=0.92 as=0.105 ps=0.92 w=0.42 l=0.15
X177 a_n3634_3911# a_n3634_3096# a_n1008_3181# VDD sky130_fd_pr__pfet_01v8 ad=0.21 pd=1.34 as=0.252 ps=2.28 w=0.84 l=0.15
X178 a_n3317_3723# b5 a_n3447_3723# GND sky130_fd_pr__nfet_01v8 ad=0.105 pd=0.92 as=0.105 ps=0.92 w=0.42 l=0.15
X179 VDD a0 a_n1008_62# VDD sky130_fd_pr__pfet_01v8 ad=0.21 pd=1.34 as=0.21 ps=1.34 w=0.84 l=0.15
X180 a_n1008_62# cin0 a_n3634_765# VDD sky130_fd_pr__pfet_01v8 ad=0.252 pd=2.28 as=0.21 ps=1.34 w=0.84 l=0.15
X181 VDD a3 a_n1008_2427# VDD sky130_fd_pr__pfet_01v8 ad=0.21 pd=1.34 as=0.21 ps=1.34 w=0.84 l=0.15
X182 a_n3634_765# b0 a_n1730_62# VDD sky130_fd_pr__pfet_01v8 ad=0.21 pd=1.34 as=0.252 ps=2.28 w=0.84 l=0.15
X183 a_n1027_4456# a6 GND GND sky130_fd_pr__nfet_01v8 ad=0.126 pd=1.44 as=0.105 ps=0.92 w=0.42 l=0.15
X184 a_n1749_n266# a0 GND GND sky130_fd_pr__nfet_01v8 ad=0.105 pd=0.92 as=0.126 ps=1.44 w=0.42 l=0.15
X185 VDD a7 a_n2911_5617# VDD sky130_fd_pr__pfet_01v8 ad=0.105 pd=0.92 as=0.105 ps=0.92 w=0.42 l=0.15
X186 VDD a4 a_n1008_3181# VDD sky130_fd_pr__pfet_01v8 ad=0.21 pd=1.34 as=0.21 ps=1.34 w=0.84 l=0.15
X187 VDD a2 a_n3317_1718# VDD sky130_fd_pr__pfet_01v8 ad=0.126 pd=1.44 as=0.105 ps=0.92 w=0.42 l=0.15
X188 VDD a7 a_n1730_5538# VDD sky130_fd_pr__pfet_01v8 ad=0.252 pd=2.28 as=0.21 ps=1.34 w=0.84 l=0.15
X189 GND a3 a_n1749_2099# GND sky130_fd_pr__nfet_01v8 ad=0.126 pd=1.44 as=0.105 ps=0.92 w=0.42 l=0.15
X190 a_n1008_3996# a_n3634_3911# a_n3634_4699# VDD sky130_fd_pr__pfet_01v8 ad=0.252 pd=2.28 as=0.21 ps=1.34 w=0.84 l=0.15
X191 a_n2911_3724# b5 GND GND sky130_fd_pr__nfet_01v8 ad=0.105 pd=0.92 as=0.105 ps=0.92 w=0.42 l=0.15
X192 a_n3317_n211# b0 a_n3447_n211# GND sky130_fd_pr__nfet_01v8 ad=0.105 pd=0.92 as=0.105 ps=0.92 w=0.42 l=0.15
X193 a_n2911_1718# a_n3634_2342# sout2 VDD sky130_fd_pr__pfet_01v8 ad=0.105 pd=0.92 as=0.126 ps=1.44 w=0.42 l=0.15
X194 a_n1730_4784# b6 a_n3634_5453# VDD sky130_fd_pr__pfet_01v8 ad=0.252 pd=2.28 as=0.21 ps=1.34 w=0.84 l=0.15
X195 a_n1730_1639# a2 VDD VDD sky130_fd_pr__pfet_01v8 ad=0.21 pd=1.34 as=0.252 ps=2.28 w=0.84 l=0.15
X196 GND a7 a_n3317_5265# GND sky130_fd_pr__nfet_01v8 ad=0.126 pd=1.44 as=0.105 ps=0.92 w=0.42 l=0.15
X197 cout7 b7 a_n1749_5210# GND sky130_fd_pr__nfet_01v8 ad=0.105 pd=0.92 as=0.126 ps=1.44 w=0.42 l=0.15
X198 a_n3447_4511# a_n3634_4699# sout6 GND sky130_fd_pr__nfet_01v8 ad=0.105 pd=0.92 as=0.126 ps=1.44 w=0.42 l=0.15
X199 VDD a_n3634_4699# a_n2911_4863# VDD sky130_fd_pr__pfet_01v8 ad=0.126 pd=1.44 as=0.105 ps=0.92 w=0.42 l=0.15
X200 a_n3317_4075# b5 a_n3447_4075# VDD sky130_fd_pr__pfet_01v8 ad=0.105 pd=0.92 as=0.105 ps=0.92 w=0.42 l=0.15
X201 a_n1008_3996# a5 VDD VDD sky130_fd_pr__pfet_01v8 ad=0.252 pd=2.28 as=0.21 ps=1.34 w=0.84 l=0.15
X202 VDD b7 a_n1008_5538# VDD sky130_fd_pr__pfet_01v8 ad=0.21 pd=1.34 as=0.252 ps=2.28 w=0.84 l=0.15
X203 a_n3447_4863# a_n3634_4699# sout6 VDD sky130_fd_pr__pfet_01v8 ad=0.105 pd=0.92 as=0.126 ps=1.44 w=0.42 l=0.15
X204 a_n3634_4699# b5 a_n1749_3668# GND sky130_fd_pr__nfet_01v8 ad=0.105 pd=0.92 as=0.126 ps=1.44 w=0.42 l=0.15
X205 a_n3317_2506# b3 a_n3447_2506# VDD sky130_fd_pr__pfet_01v8 ad=0.105 pd=0.92 as=0.105 ps=0.92 w=0.42 l=0.15
X206 GND a0 a_n1027_n266# GND sky130_fd_pr__nfet_01v8 ad=0.105 pd=0.92 as=0.105 ps=0.92 w=0.42 l=0.15
X207 a_n3317_1366# b2 a_n3447_1366# GND sky130_fd_pr__nfet_01v8 ad=0.105 pd=0.92 as=0.105 ps=0.92 w=0.42 l=0.15
X208 GND a_n3634_5453# a_n2911_5266# GND sky130_fd_pr__nfet_01v8 ad=0.126 pd=1.44 as=0.105 ps=0.92 w=0.42 l=0.15
X209 GND b7 a_n1027_5210# GND sky130_fd_pr__nfet_01v8 ad=0.105 pd=0.92 as=0.126 ps=1.44 w=0.42 l=0.15
X210 a_n3634_5453# a_n3634_4699# a_n1008_4784# VDD sky130_fd_pr__pfet_01v8 ad=0.21 pd=1.34 as=0.252 ps=2.28 w=0.84 l=0.15
X211 a_n3317_3260# b4 a_n3447_3260# VDD sky130_fd_pr__pfet_01v8 ad=0.105 pd=0.92 as=0.105 ps=0.92 w=0.42 l=0.15
X212 a_n1008_2427# a_n3634_2342# a_n3634_3096# VDD sky130_fd_pr__pfet_01v8 ad=0.252 pd=2.28 as=0.21 ps=1.34 w=0.84 l=0.15
X213 a_n1027_2099# a3 GND GND sky130_fd_pr__nfet_01v8 ad=0.126 pd=1.44 as=0.105 ps=0.92 w=0.42 l=0.15
X214 a_n2911_n210# b0 GND GND sky130_fd_pr__nfet_01v8 ad=0.105 pd=0.92 as=0.105 ps=0.92 w=0.42 l=0.15
X215 a_n3634_3911# b4 a_n1749_2853# GND sky130_fd_pr__nfet_01v8 ad=0.105 pd=0.92 as=0.126 ps=1.44 w=0.42 l=0.15
X216 a_n1008_3181# a_n3634_3096# a_n3634_3911# VDD sky130_fd_pr__pfet_01v8 ad=0.252 pd=2.28 as=0.21 ps=1.34 w=0.84 l=0.15
X217 GND b5 a_n1027_3668# GND sky130_fd_pr__nfet_01v8 ad=0.105 pd=0.92 as=0.126 ps=1.44 w=0.42 l=0.15
X218 GND a5 a_n3317_3723# GND sky130_fd_pr__nfet_01v8 ad=0.126 pd=1.44 as=0.105 ps=0.92 w=0.42 l=0.15
X219 a_n2911_1367# b2 GND GND sky130_fd_pr__nfet_01v8 ad=0.105 pd=0.92 as=0.105 ps=0.92 w=0.42 l=0.15
X220 a_n1008_2427# a3 VDD VDD sky130_fd_pr__pfet_01v8 ad=0.252 pd=2.28 as=0.21 ps=1.34 w=0.84 l=0.15
X221 VDD a6 a_n1008_4784# VDD sky130_fd_pr__pfet_01v8 ad=0.21 pd=1.34 as=0.21 ps=1.34 w=0.84 l=0.15
X222 GND b4 a_n1027_2853# GND sky130_fd_pr__nfet_01v8 ad=0.105 pd=0.92 as=0.126 ps=1.44 w=0.42 l=0.15
X223 GND a0 a_n1749_n266# GND sky130_fd_pr__nfet_01v8 ad=0.126 pd=1.44 as=0.105 ps=0.92 w=0.42 l=0.15
X224 a_n1008_3181# a4 VDD VDD sky130_fd_pr__pfet_01v8 ad=0.252 pd=2.28 as=0.21 ps=1.34 w=0.84 l=0.15
X225 a_n3447_2154# a_n3634_2342# sout3 GND sky130_fd_pr__nfet_01v8 ad=0.105 pd=0.92 as=0.126 ps=1.44 w=0.42 l=0.15
X226 a_n2911_578# b1 GND GND sky130_fd_pr__nfet_01v8 ad=0.105 pd=0.92 as=0.105 ps=0.92 w=0.42 l=0.15
X227 GND a_n3634_3911# a_n2911_3724# GND sky130_fd_pr__nfet_01v8 ad=0.126 pd=1.44 as=0.105 ps=0.92 w=0.42 l=0.15
X228 GND a0 a_n3317_n211# GND sky130_fd_pr__nfet_01v8 ad=0.126 pd=1.44 as=0.105 ps=0.92 w=0.42 l=0.15
X229 VDD a2 a_n2911_1718# VDD sky130_fd_pr__pfet_01v8 ad=0.105 pd=0.92 as=0.105 ps=0.92 w=0.42 l=0.15
X230 a_n1730_3996# a5 VDD VDD sky130_fd_pr__pfet_01v8 ad=0.21 pd=1.34 as=0.252 ps=2.28 w=0.84 l=0.15
X231 VDD a2 a_n1730_1639# VDD sky130_fd_pr__pfet_01v8 ad=0.252 pd=2.28 as=0.21 ps=1.34 w=0.84 l=0.15
X232 a_n1749_5210# b7 cout7 GND sky130_fd_pr__nfet_01v8 ad=0.126 pd=1.44 as=0.105 ps=0.92 w=0.42 l=0.15
X233 a_n3317_4511# b6 a_n3447_4511# GND sky130_fd_pr__nfet_01v8 ad=0.105 pd=0.92 as=0.105 ps=0.92 w=0.42 l=0.15
X234 VDD a5 a_n3317_4075# VDD sky130_fd_pr__pfet_01v8 ad=0.126 pd=1.44 as=0.105 ps=0.92 w=0.42 l=0.15
X235 a_n1008_5538# b7 VDD VDD sky130_fd_pr__pfet_01v8 ad=0.21 pd=1.34 as=0.21 ps=1.34 w=0.84 l=0.15
X236 a_n3317_4863# b6 a_n3447_4863# VDD sky130_fd_pr__pfet_01v8 ad=0.105 pd=0.92 as=0.105 ps=0.92 w=0.42 l=0.15
X237 a_n1749_3668# b5 a_n3634_4699# GND sky130_fd_pr__nfet_01v8 ad=0.126 pd=1.44 as=0.105 ps=0.92 w=0.42 l=0.15
X238 VDD a3 a_n3317_2506# VDD sky130_fd_pr__pfet_01v8 ad=0.126 pd=1.44 as=0.105 ps=0.92 w=0.42 l=0.15
X239 a_n1027_n266# a0 GND GND sky130_fd_pr__nfet_01v8 ad=0.126 pd=1.44 as=0.105 ps=0.92 w=0.42 l=0.15
X240 a_n1008_62# b0 VDD VDD sky130_fd_pr__pfet_01v8 ad=0.21 pd=1.34 as=0.21 ps=1.34 w=0.84 l=0.15
X241 GND a_n3634_765# a_n2911_578# GND sky130_fd_pr__nfet_01v8 ad=0.126 pd=1.44 as=0.105 ps=0.92 w=0.42 l=0.15
X242 a_n2911_2909# a_n3634_3911# sout4 GND sky130_fd_pr__nfet_01v8 ad=0.105 pd=0.92 as=0.126 ps=1.44 w=0.42 l=0.15
X243 a_n3634_2342# b2 a_n1749_1311# GND sky130_fd_pr__nfet_01v8 ad=0.105 pd=0.92 as=0.126 ps=1.44 w=0.42 l=0.15
X244 GND a2 a_n3317_1366# GND sky130_fd_pr__nfet_01v8 ad=0.126 pd=1.44 as=0.105 ps=0.92 w=0.42 l=0.15
X245 a_n1027_5210# b7 GND GND sky130_fd_pr__nfet_01v8 ad=0.105 pd=0.92 as=0.105 ps=0.92 w=0.42 l=0.15
X246 a_n1008_4784# a_n3634_4699# a_n3634_5453# VDD sky130_fd_pr__pfet_01v8 ad=0.252 pd=2.28 as=0.21 ps=1.34 w=0.84 l=0.15
X247 a_n2911_4512# b6 GND GND sky130_fd_pr__nfet_01v8 ad=0.105 pd=0.92 as=0.105 ps=0.92 w=0.42 l=0.15
X248 a_n2911_4075# a_n3634_4699# sout5 VDD sky130_fd_pr__pfet_01v8 ad=0.105 pd=0.92 as=0.126 ps=1.44 w=0.42 l=0.15
X249 VDD a4 a_n3317_3260# VDD sky130_fd_pr__pfet_01v8 ad=0.126 pd=1.44 as=0.105 ps=0.92 w=0.42 l=0.15
X250 GND cin0 a_n2911_n210# GND sky130_fd_pr__nfet_01v8 ad=0.126 pd=1.44 as=0.105 ps=0.92 w=0.42 l=0.15
X251 cout7 a_n3634_5453# a_n1027_5210# GND sky130_fd_pr__nfet_01v8 ad=0.105 pd=0.92 as=0.126 ps=1.44 w=0.42 l=0.15
X252 a_n1749_2853# b4 a_n3634_3911# GND sky130_fd_pr__nfet_01v8 ad=0.126 pd=1.44 as=0.105 ps=0.92 w=0.42 l=0.15
X253 a_n2911_2506# a_n3634_3096# sout3 VDD sky130_fd_pr__pfet_01v8 ad=0.105 pd=0.92 as=0.126 ps=1.44 w=0.42 l=0.15
X254 a_n1730_850# a1 VDD VDD sky130_fd_pr__pfet_01v8 ad=0.21 pd=1.34 as=0.252 ps=2.28 w=0.84 l=0.15
X255 VDD b2 a_n1008_1639# VDD sky130_fd_pr__pfet_01v8 ad=0.21 pd=1.34 as=0.252 ps=2.28 w=0.84 l=0.15
X256 a_n1027_3668# b5 GND GND sky130_fd_pr__nfet_01v8 ad=0.105 pd=0.92 as=0.105 ps=0.92 w=0.42 l=0.15
X257 a_n2911_3260# a_n3634_3911# sout4 VDD sky130_fd_pr__pfet_01v8 ad=0.105 pd=0.92 as=0.126 ps=1.44 w=0.42 l=0.15
X258 a_n1730_2427# a3 VDD VDD sky130_fd_pr__pfet_01v8 ad=0.21 pd=1.34 as=0.252 ps=2.28 w=0.84 l=0.15
X259 a_n3634_4699# a_n3634_3911# a_n1027_3668# GND sky130_fd_pr__nfet_01v8 ad=0.105 pd=0.92 as=0.126 ps=1.44 w=0.42 l=0.15
X260 a_n1730_3181# a4 VDD VDD sky130_fd_pr__pfet_01v8 ad=0.21 pd=1.34 as=0.252 ps=2.28 w=0.84 l=0.15
X261 a_n3634_765# cin0 a_n1008_62# VDD sky130_fd_pr__pfet_01v8 ad=0.21 pd=1.34 as=0.252 ps=2.28 w=0.84 l=0.15
X262 GND b2 a_n1027_1311# GND sky130_fd_pr__nfet_01v8 ad=0.105 pd=0.92 as=0.126 ps=1.44 w=0.42 l=0.15
X263 GND a_n3634_1554# a_n2911_1367# GND sky130_fd_pr__nfet_01v8 ad=0.126 pd=1.44 as=0.105 ps=0.92 w=0.42 l=0.15
X264 a_n1008_4784# a6 VDD VDD sky130_fd_pr__pfet_01v8 ad=0.252 pd=2.28 as=0.21 ps=1.34 w=0.84 l=0.15
X265 a_n3634_5453# b6 a_n1749_4456# GND sky130_fd_pr__nfet_01v8 ad=0.105 pd=0.92 as=0.126 ps=1.44 w=0.42 l=0.15
X266 a_n1027_2853# b4 GND GND sky130_fd_pr__nfet_01v8 ad=0.105 pd=0.92 as=0.105 ps=0.92 w=0.42 l=0.15
X267 a_n1749_522# a1 GND GND sky130_fd_pr__nfet_01v8 ad=0.105 pd=0.92 as=0.126 ps=1.44 w=0.42 l=0.15
X268 a_n2911_578# a_n3634_1554# sout1 GND sky130_fd_pr__nfet_01v8 ad=0.105 pd=0.92 as=0.126 ps=1.44 w=0.42 l=0.15
X269 a_n3447_929# a_n3634_765# sout1 VDD sky130_fd_pr__pfet_01v8 ad=0.105 pd=0.92 as=0.126 ps=1.44 w=0.42 l=0.15
X270 a_n3634_3911# a_n3634_3096# a_n1027_2853# GND sky130_fd_pr__nfet_01v8 ad=0.105 pd=0.92 as=0.126 ps=1.44 w=0.42 l=0.15
X271 a_n3317_2154# b3 a_n3447_2154# GND sky130_fd_pr__nfet_01v8 ad=0.105 pd=0.92 as=0.105 ps=0.92 w=0.42 l=0.15
C0 b6 a_n1027_5210# 0.008812f
C1 a_n2911_4075# a_n1008_3996# 4.52e-22
C2 a_n1027_3668# a_n1027_4456# 0.004712f
C3 b0 a_n3447_577# 5.36e-20
C4 b7 a7 1.02288f
C5 a_n2911_1367# a1 7.57e-19
C6 b1 a_n3634_765# 0.614484f
C7 a_n2911_n210# a0 0.045558f
C8 a_n3634_1554# b0 1.33e-19
C9 a_n1749_5210# VDD 0.025442f
C10 a_n1008_62# a_n1730_62# 0.032245f
C11 a_n1027_2099# a2 0.003191f
C12 VDD a_n1008_1639# 0.627791f
C13 a1 a2 0.038052f
C14 cout7 a_n1008_5538# 0.122302f
C15 a_n3634_4699# a_n1730_3996# 0.125919f
C16 a_n3447_4511# b5 5.36e-20
C17 a_n3447_4075# sout6 1.45e-19
C18 a_n1027_522# a_n2911_578# 7.89e-21
C19 a3 a_n1008_1639# 2.72e-19
C20 sout2 a_n3634_3096# 0.003071f
C21 a_n3634_1554# a_n2911_929# 0.007989f
C22 a_n3634_5453# a_n1730_5538# 0.05695f
C23 a_n3634_3096# a_n1730_3181# 0.05695f
C24 a_n3317_4075# VDD 0.029633f
C25 a5 a_n3634_3911# 0.228839f
C26 a_n1749_n266# a_n1730_62# 0.00772f
C27 a_n3317_3723# b5 0.002741f
C28 a_n3317_4863# sout7 2.25e-19
C29 sout3 b2 2.06e-19
C30 a_n2911_5617# a_n1730_5538# 1.25e-19
C31 a_n1730_2427# a4 4.99e-19
C32 VDD a_n2911_2506# 0.142768f
C33 a_n1749_3668# a_n1730_3996# 0.00772f
C34 a_n2911_1367# a_n3634_2342# 0.132214f
C35 a_n2911_141# VDD 0.142768f
C36 a_n3447_3260# sout5 1.35e-19
C37 a_n3317_4511# a_n3634_3911# 5.59e-19
C38 a1 a_n1008_850# 0.169292f
C39 a3 a_n2911_2506# 0.074154f
C40 a_n1027_1311# b2 0.177862f
C41 sout0 a0 0.119864f
C42 a_n3317_3260# a_n3634_3911# 7.22e-19
C43 a_n3447_2154# b2 5.36e-20
C44 b4 b5 0.019641f
C45 a_n1027_5210# a_n1027_4456# 0.004936f
C46 b3 a_n2911_1718# 4.44e-19
C47 a_n1008_4784# a7 2.95e-19
C48 a_n3634_5453# a6 0.638448f
C49 a_n2911_4863# a_n3634_4699# 0.019818f
C50 b1 a_n1730_62# 1.75e-19
C51 a2 a_n3634_2342# 0.638273f
C52 b6 a_n3634_5453# 0.904296f
C53 sout6 a7 0.004871f
C54 a_n2911_2909# a_n1749_2853# 1.46e-19
C55 cout7 a_n1027_5210# 0.100336f
C56 a_n3634_765# a_n3447_577# 0.002776f
C57 b4 a_n1027_2853# 0.177862f
C58 a_n2911_2909# VDD 0.003504f
C59 sout2 a_n1749_1311# 8.56e-21
C60 a6 a_n1730_4784# 0.033659f
C61 VDD a_n1730_5538# 0.362606f
C62 b6 a_n1730_4784# 0.26536f
C63 a_n2911_2909# a3 8.16e-19
C64 a_n3634_1554# a_n3634_765# 0.554539f
C65 a_n2911_3724# a_n3634_3096# 0.001416f
C66 b7 a_n1008_5538# 0.201653f
C67 b1 a_n1749_1311# 4.86e-19
C68 b3 a4 9.03e-19
C69 a_n1749_2099# a_n3634_1554# 0.07824f
C70 a_n1027_3668# a_n3634_3911# 0.066859f
C71 a5 sout6 5.56e-19
C72 a_n1027_n266# a0 0.148957f
C73 a_n3447_2908# b4 0.010473f
C74 a_n1008_62# a_n1027_522# 0.015383f
C75 a_n1008_3181# b5 6.48e-20
C76 a_n1008_2427# a4 2.95e-19
C77 a_n1749_4456# a_n3634_4699# 0.01644f
C78 a_n3317_4863# a_n3447_4863# 0.014951f
C79 a_n3317_2154# a_n3317_1718# 0.002272f
C80 a_n3317_4511# sout6 0.01501f
C81 sout4 a_n3634_3096# 0.111015f
C82 a6 VDD 0.60027f
C83 b6 VDD 1.0193f
C84 a_n1027_2853# a_n1008_3181# 0.009429f
C85 a4 a_n3317_2506# 1.15e-19
C86 a_n1749_522# b0 4.89e-19
C87 a_n1749_5210# a_n1730_5538# 0.00772f
C88 a_n3634_3096# a_n3634_1554# 0.019576f
C89 a_n2911_4075# a6 0.006839f
C90 a_n3634_5453# sout5 0.003071f
C91 sout0 a1 0.004592f
C92 a_n3634_2342# a_n3317_1718# 7.67e-19
C93 a_n2911_929# b2 4.43e-19
C94 a_n2911_4075# b6 4.44e-19
C95 b0 a0 1.02288f
C96 a_n3317_577# VDD 0.001014f
C97 a6 a_n1008_3996# 2.72e-19
C98 b6 a_n1008_3996# 7.07e-20
C99 a_n3634_5453# a_n2911_4512# 0.132214f
C100 a_n1749_4456# a_n1749_3668# 6.28e-19
C101 a_n2911_1367# VDD 0.003001f
C102 a_n3634_5453# a_n1027_4456# 0.100409f
C103 a_n1027_5210# b7 0.177862f
C104 a_n1027_2099# a_n1027_1311# 0.004712f
C105 VDD a_n2911_3260# 0.142768f
C106 a_n2911_2155# a_n3634_1554# 0.001512f
C107 a1 a_n1027_1311# 0.003184f
C108 a_n3317_929# a_n3634_765# 0.002421f
C109 a_n3634_5453# cout7 0.290454f
C110 sout4 a_n3447_3723# 4.53e-19
C111 a_n1008_4784# a_n1008_5538# 3.29e-19
C112 a_n3317_2908# a_n3634_2342# 6.03e-19
C113 a6 a_n1749_5210# 7.31e-19
C114 b1 a_n1027_522# 0.177862f
C115 a2 VDD 0.600149f
C116 a1 a_n1027_n266# 1.76e-19
C117 b6 a_n1749_5210# 6.13e-19
C118 a_n2911_2909# a_n2911_2506# 0.00742f
C119 a3 a2 0.038139f
C120 a_n3447_2506# a_n3634_2342# 0.003618f
C121 a_n2911_5617# cout7 0.005623f
C122 sout5 VDD 0.154308f
C123 a_n3634_1554# a_n1749_1311# 0.01644f
C124 sout2 b3 0.001868f
C125 a_n3447_3260# a_n3634_3911# 7.22e-19
C126 a_n2911_4075# sout5 0.034167f
C127 a_n3317_2154# sout3 0.01501f
C128 b3 a_n3447_1718# 2.4e-19
C129 a_n3634_765# b2 0.002985f
C130 a_n3317_4075# a6 1.04e-19
C131 VDD a_n2911_4512# 0.003014f
C132 sout3 a_n3634_2342# 0.111002f
C133 a_n1749_2099# b2 4.89e-19
C134 VDD a_n1027_4456# 0.030343f
C135 a1 b0 8.04e-19
C136 a_n2911_4075# a_n2911_4512# 0.006752f
C137 b4 a_n1008_3181# 0.201653f
C138 a_n3317_2154# a_n3447_2154# 0.014951f
C139 a_n3317_4863# a_n3634_4699# 0.002421f
C140 a_n3634_2342# a_n3634_3911# 0.022241f
C141 a_n1027_1311# a_n3634_2342# 0.100409f
C142 sout7 a_n3447_4863# 1.59e-19
C143 cout7 VDD 0.222845f
C144 a_n2911_4863# a_n2911_5266# 0.00742f
C145 a_n1749_522# a_n3634_765# 0.01644f
C146 VDD a_n1008_850# 0.627791f
C147 cin0 a_n3317_141# 0.002421f
C148 a_n3634_3096# a5 0.008181f
C149 a_n3447_2154# a_n3634_2342# 0.002776f
C150 a_n3634_765# a0 0.639831f
C151 a_n1027_4456# a_n1008_3996# 0.015383f
C152 a_n3634_4699# b5 0.904036f
C153 a2 a_n1008_1639# 0.169292f
C154 a1 a_n2911_929# 0.074154f
C155 VDD a_n3317_1718# 0.029633f
C156 a_n1008_4784# a_n1027_5210# 0.017037f
C157 a_n3317_5617# b7 0.004341f
C158 a3 a_n3317_1718# 1.04e-19
C159 a_n3634_5453# b7 0.613254f
C160 a_n3634_3096# b2 1.33e-19
C161 a_n3634_3096# a_n3317_3260# 0.002421f
C162 a_n1730_4784# b7 2.04e-19
C163 a_n3447_929# a_n3634_765# 0.003618f
C164 a_n3447_n211# VDD 1.02e-19
C165 sout5 a_n3317_4075# 0.018476f
C166 a_n2911_5617# b7 0.073347f
C167 a4 b5 2.82e-20
C168 a_n1027_522# a_n3634_1554# 0.100409f
C169 a_n2911_2155# b2 6.54e-19
C170 a_n3634_5453# a_n3634_3911# 0.019576f
C171 a_n3317_5265# a7 0.001953f
C172 cout7 a_n1749_5210# 0.150082f
C173 a_n1749_3668# b5 0.036154f
C174 a_n3317_2908# a_n1749_2853# 8.29e-21
C175 a_n3447_4511# a_n3634_4699# 0.002776f
C176 a_n3317_2908# VDD 0.001153f
C177 a_n1008_1639# a_n1008_850# 3.12e-19
C178 a_n1027_2853# a4 0.148957f
C179 a_n3634_3096# a_n1027_3668# 0.024499f
C180 VDD a_n3447_2506# 0.01215f
C181 sout4 b3 2.28e-19
C182 a_n2911_929# a_n3634_2342# 1.4e-20
C183 b6 a6 1.02288f
C184 sout0 VDD 0.15053f
C185 VDD b7 1.02719f
C186 a_n1749_522# a_n1730_62# 0.004828f
C187 a_n3317_3723# a_n3634_4699# 4.61e-20
C188 a_n1749_1311# b2 0.036154f
C189 b3 a_n3634_1554# 0.002999f
C190 a1 a_n3634_765# 0.228873f
C191 a_n1027_2099# a_n1749_2099# 0.019488f
C192 a_n1730_62# a0 0.033659f
C193 sout3 VDD 0.154726f
C194 VDD a_n3447_141# 0.01215f
C195 sout3 a3 0.119864f
C196 a_n1749_2853# a_n3634_3911# 0.150082f
C197 sout7 a_n3634_4699# 0.002135f
C198 a_n1749_522# a_n1749_1311# 6.27e-19
C199 VDD a_n3634_3911# 1.39782f
C200 a_n1027_1311# VDD 0.030264f
C201 a_n3634_5453# a_n1008_4784# 0.132417f
C202 sout4 a_n3317_2506# 2.25e-19
C203 a3 a_n3634_3911# 7.04e-19
C204 b4 a_n3634_4699# 1.2e-19
C205 a_n3447_2154# VDD 9.21e-19
C206 a3 a_n1027_1311# 1.76e-19
C207 a_n2911_4075# a_n3634_3911# 0.019818f
C208 a_n3634_5453# sout6 0.088013f
C209 a_n1008_4784# a_n1730_4784# 0.032245f
C210 cin0 sout1 0.001929f
C211 VDD a_n1027_n266# 0.008314f
C212 a_n1730_1639# a_n2911_1718# 1.25e-19
C213 a_n1008_3996# a_n3634_3911# 0.04147f
C214 a_n1749_3668# a_n3317_3723# 8.29e-21
C215 a_n1027_2099# a_n3634_3096# 0.100409f
C216 cin0 a_n2911_578# 0.001512f
C217 a_n1730_4784# sout6 7.26e-20
C218 a5 a_n1730_3996# 0.033659f
C219 a_n1749_5210# b7 0.036154f
C220 cout7 a_n1730_5538# 0.122573f
C221 sout1 a_n3317_141# 2.04e-19
C222 sout5 a6 0.004592f
C223 a_n3317_2154# a_n1749_2099# 8.29e-21
C224 b6 sout5 0.001868f
C225 a_n3634_765# a_n3634_2342# 0.019507f
C226 cin0 a_n3317_n211# 0.001568f
C227 b4 a4 1.02288f
C228 a_n1027_2099# a_n2911_2155# 7.89e-21
C229 a_n1749_2099# a_n3634_2342# 0.01644f
C230 a_n1749_3668# b4 4.15e-19
C231 b5 a_n1730_3181# 1.55e-19
C232 a6 a_n2911_4512# 0.045558f
C233 VDD b0 1.00565f
C234 b6 a_n2911_4512# 0.007386f
C235 a_n2911_4863# a7 0.007303f
C236 a_n1027_1311# a_n1008_1639# 0.009429f
C237 a_n3447_3260# a_n3634_3096# 0.003618f
C238 a_n1008_4784# VDD 0.627795f
C239 a_n3447_1366# a_n3317_1366# 0.014951f
C240 a_n2911_1367# a2 0.045558f
C241 a6 a_n1027_4456# 0.148957f
C242 a1 a_n1730_62# 4.38e-19
C243 a_n1027_522# b2 1.74e-19
C244 b6 a_n1027_4456# 0.177862f
C245 VDD sout6 0.154726f
C246 a6 cout7 7.04e-19
C247 a_n3447_4863# a_n3634_4699# 0.003618f
C248 a_n3317_2154# a_n3634_3096# 4.61e-20
C249 b6 cout7 1.53e-19
C250 a_n2911_141# sout0 0.034167f
C251 a_n2911_929# VDD 0.142768f
C252 a_n1749_522# a_n1027_522# 0.019488f
C253 a1 a_n1749_1311# 6.65e-19
C254 a_n1008_4784# a_n1008_3996# 3.13e-19
C255 a_n3317_4075# a_n3634_3911# 0.002421f
C256 a_n3634_3096# a_n3634_2342# 0.568869f
C257 sout1 a_n1730_850# 7.26e-20
C258 sout3 a_n2911_2506# 0.034167f
C259 a_n3447_1366# sout1 4.95e-19
C260 a_n1027_522# a0 0.003191f
C261 b3 b2 0.021185f
C262 a4 a_n1008_3181# 0.169292f
C263 a_n2911_2506# a_n3634_3911# 1.57e-20
C264 a_n1749_4456# a7 1.06e-19
C265 a_n3447_3260# a_n3447_3723# 0.002124f
C266 b7 a_n1730_5538# 0.26536f
C267 a_n2911_2155# a_n3634_2342# 0.012035f
C268 a_n2911_3724# b5 0.007386f
C269 cin0 a_n1008_62# 0.029885f
C270 a_n3317_1366# sout1 4.95e-19
C271 a2 a_n1008_850# 2.72e-19
C272 a_n2911_2909# a_n3634_3911# 0.132214f
C273 a_n1749_4456# a5 6.66e-19
C274 a2 a_n3317_1718# 0.001237f
C275 a_n1027_4456# a_n2911_4512# 7.89e-21
C276 a_n1749_1311# a_n3634_2342# 0.150082f
C277 sout4 b5 0.001765f
C278 a_n3317_4075# sout6 2.04e-19
C279 cin0 a_n1749_n266# 0.009704f
C280 VDD a_n3634_765# 1.39408f
C281 sout2 a_n1730_1639# 7.26e-20
C282 a_n1749_4456# a_n3317_4511# 8.29e-21
C283 a6 b7 3.42e-20
C284 a_n2911_5266# sout7 0.041347f
C285 a_n1749_2099# a_n1749_2853# 6.57e-19
C286 b4 a_n1730_3181# 0.26536f
C287 b6 b7 0.023614f
C288 sout1 a_n2911_578# 0.041347f
C289 a_n1749_2099# VDD 0.02507f
C290 a_n2911_141# b0 0.073347f
C291 a_n3447_4075# b5 0.004422f
C292 a_n1749_2099# a3 0.065929f
C293 a_n1027_522# a1 0.148957f
C294 sout0 a_n3317_577# 4.97e-19
C295 a6 a_n3634_3911# 0.008974f
C296 b6 a_n3634_3911# 0.002999f
C297 cin0 b1 0.002194f
C298 sout4 a_n3447_2908# 0.031223f
C299 a_n3634_3096# a_n1749_2853# 0.016361f
C300 a_n3634_3096# VDD 1.40508f
C301 b3 a_n1027_2099# 0.177862f
C302 a_n3634_3096# a3 0.638448f
C303 a_n3317_5617# a_n3447_5617# 0.014951f
C304 a_n1008_3181# a_n1730_3181# 0.032245f
C305 a_n3634_5453# a_n3447_5265# 0.002776f
C306 a_n3317_4863# a7 1.15e-19
C307 a_n3447_5617# a_n3634_5453# 0.003618f
C308 a_n3447_4511# a_n3447_4075# 0.002272f
C309 a_n2911_1367# a_n1027_1311# 7.89e-21
C310 a_n2911_3260# a_n3634_3911# 0.007849f
C311 a_n1730_2427# a_n3634_2342# 0.056654f
C312 a_n3317_5265# a_n3634_5453# 0.001568f
C313 a_n3634_4699# a4 5.86e-19
C314 sout3 a2 5.56e-19
C315 a_n2911_2155# VDD 0.003014f
C316 a_n2911_3724# b4 6.2e-19
C317 a_n1749_3668# a_n3634_4699# 0.150082f
C318 a_n1027_2099# a_n1008_2427# 0.009429f
C319 sout4 a_n3317_3723# 4.53e-19
C320 a_n2911_2155# a3 0.045558f
C321 VDD a_n1730_62# 0.361996f
C322 a2 a_n1027_1311# 0.148957f
C323 a_n1008_4784# a6 0.169292f
C324 b6 a_n1008_4784# 0.201653f
C325 sout5 a_n3634_3911# 0.110993f
C326 sout2 a_n3447_1366# 0.031223f
C327 a_n3447_3723# VDD 8.31e-19
C328 a_n1027_4456# b7 1.93e-19
C329 a6 sout6 0.119864f
C330 b6 sout6 0.16871f
C331 sout4 b4 0.16871f
C332 a_n3317_2154# b3 0.002741f
C333 a5 b5 1.02288f
C334 cout7 b7 0.894798f
C335 b1 a_n1730_850# 0.26536f
C336 VDD a_n1749_1311# 0.02506f
C337 a_n1749_3668# a4 6.22e-19
C338 a_n2911_141# a_n3634_765# 0.007995f
C339 b1 a_n3447_1366# 5.34e-20
C340 a_n2911_4512# a_n3634_3911# 0.001512f
C341 a3 a_n1749_1311# 9.55e-20
C342 a_n3447_5265# VDD 0.00106f
C343 b3 a_n3634_2342# 0.614484f
C344 sout0 a_n2911_n210# 0.041347f
C345 a_n1730_1639# a_n3634_1554# 0.056654f
C346 a5 a_n1027_2853# 1.63e-19
C347 a_n1027_4456# a_n3634_3911# 0.031007f
C348 a_n3447_5617# VDD 0.01215f
C349 cin0 a_n3447_577# 5.59e-19
C350 a_n3317_5265# VDD 0.001153f
C351 sout2 a_n3317_1366# 0.01501f
C352 sout3 a_n3317_1718# 2.04e-19
C353 a_n1027_1311# a_n1008_850# 0.015338f
C354 cin0 a_n3634_1554# 0.016487f
C355 a_n1008_2427# a_n3634_2342# 0.041476f
C356 a_n2911_1367# a_n2911_929# 0.006734f
C357 a_n3447_n211# sout0 0.031223f
C358 a_n3634_3096# a_n2911_2506# 0.008197f
C359 a_n3634_2342# a_n3317_2506# 0.002421f
C360 sout2 sout1 0.011736f
C361 a_n3317_n211# a_n1749_n266# 8.29e-21
C362 sout5 sout6 0.01176f
C363 a_n2911_n210# a_n1027_n266# 7.89e-21
C364 a2 a_n2911_929# 0.006826f
C365 a_n1027_3668# b5 0.177862f
C366 sout7 a7 0.119864f
C367 a_n1730_2427# a_n1749_2853# 0.005351f
C368 a_n3447_4511# a_n3317_4511# 0.014951f
C369 b1 sout1 0.16871f
C370 b1 a_n2911_578# 0.007386f
C371 a_n1730_2427# VDD 0.361997f
C372 a_n3317_2908# sout3 5.62e-19
C373 a_n3317_5265# a_n1749_5210# 8.29e-21
C374 VDD a_n1730_3996# 0.361997f
C375 a_n1008_4784# a_n1027_4456# 0.009429f
C376 a_n2911_4863# a_n3634_5453# 0.008197f
C377 a_n3634_3096# a_n2911_2909# 0.012035f
C378 sout2 a_n2911_1718# 0.034167f
C379 a_n3317_3723# a5 0.001953f
C380 a_n2911_4512# sout6 0.041347f
C381 a_n1027_3668# a_n1027_2853# 0.004548f
C382 a_n1730_2427# a3 0.033659f
C383 a_n2911_4075# a_n1730_3996# 1.25e-19
C384 sout3 a_n3447_2506# 0.036174f
C385 a_n2911_5266# a_n3634_4699# 0.001648f
C386 a_n1027_522# VDD 0.030343f
C387 a_n3317_2908# a_n3634_3911# 4.61e-20
C388 a_n2911_141# a_n1730_62# 1.25e-19
C389 a_n2911_4863# a_n1730_4784# 1.25e-19
C390 cout7 sout6 0.003273f
C391 sout0 a_n3447_141# 0.036174f
C392 a_n2911_n210# b0 0.007386f
C393 a_n1730_3996# a_n1008_3996# 0.032245f
C394 a_n3317_577# a_n3634_765# 0.001568f
C395 a_n3634_1554# a_n1730_850# 0.125912f
C396 a5 b4 7.37e-19
C397 a_n3447_1366# a_n3634_1554# 0.002776f
C398 a_n3317_3260# a_n3317_3723# 0.002124f
C399 a_n2911_929# a_n1008_850# 4.52e-22
C400 a_n2911_1367# a_n3634_765# 0.001509f
C401 a4 a_n1730_3181# 0.033659f
C402 b3 a_n1749_2853# 6.13e-19
C403 a_n1749_3668# a_n1730_3181# 0.004475f
C404 sout3 a_n3634_3911# 0.003273f
C405 b3 VDD 1.0193f
C406 a_n3447_n211# b0 0.010473f
C407 a_n1749_4456# a_n3634_5453# 0.150082f
C408 b3 a3 1.02288f
C409 a_n3447_2154# sout3 0.031223f
C410 a_n1730_1639# b2 0.26536f
C411 a_n2911_4863# VDD 0.142768f
C412 a2 a_n3634_765# 0.008942f
C413 a_n3317_3260# b4 0.004341f
C414 a_n1749_4456# a_n1730_4784# 0.00772f
C415 a_n3317_1366# a_n3634_1554# 0.001568f
C416 a_n1749_2099# a2 6.66e-19
C417 a_n2911_3724# a_n3634_4699# 0.132214f
C418 a_n1027_2099# a_n1027_2853# 0.004936f
C419 a_n1008_2427# VDD 0.627795f
C420 a_n1008_2427# a3 0.169292f
C421 a5 a_n1008_3181# 2.56e-19
C422 VDD a_n3317_2506# 0.029633f
C423 a_n3634_3096# a_n2911_3260# 0.019818f
C424 sout1 a_n3447_577# 0.031223f
C425 a3 a_n3317_2506# 0.001237f
C426 sout0 b0 0.16871f
C427 a_n3447_3260# b5 2.2e-19
C428 b1 a_n1008_62# 7.07e-20
C429 a_n1008_4784# b7 7.93e-20
C430 sout1 a_n3634_1554# 0.087693f
C431 a_n1027_3668# b4 0.007851f
C432 cin0 a_n1749_522# 0.076779f
C433 a_n3634_1554# a_n2911_578# 0.132214f
C434 sout4 a_n3634_4699# 0.002928f
C435 a_n3634_3096# a2 6.34e-19
C436 a_n1730_2427# a_n2911_2506# 1.25e-19
C437 b0 a_n3447_141# 0.004422f
C438 sout6 b7 0.002016f
C439 a_n2911_3724# a4 7.18e-19
C440 b3 a_n1008_1639# 7.07e-20
C441 a_n3634_765# a_n1008_850# 0.041476f
C442 a_n1749_4456# VDD 0.02507f
C443 cin0 a0 0.089922f
C444 a_n1749_3668# a_n2911_3724# 1.46e-19
C445 a_n3634_3096# sout5 0.001786f
C446 a_n3634_4699# a_n3447_4075# 7.67e-19
C447 a_n3634_1554# a_n2911_1718# 0.019818f
C448 b6 a_n3447_5265# 6.01e-20
C449 a_n2911_n210# a_n3634_765# 0.132214f
C450 a_n3317_141# a0 0.001237f
C451 sout6 a_n3634_3911# 0.001929f
C452 a_n1008_2427# a_n1008_1639# 3.13e-19
C453 a_n2911_2155# a2 7.59e-19
C454 a_n1027_2853# a_n3634_2342# 0.046544f
C455 a_n1027_n266# b0 0.177862f
C456 sout4 a4 0.119864f
C457 sout2 a_n3447_1718# 0.036174f
C458 a_n2911_1367# a_n1749_1311# 1.46e-19
C459 a_n3317_1366# a_n3317_929# 0.002266f
C460 a_n1027_3668# a_n1008_3181# 0.014271f
C461 b2 a_n1730_850# 1.74e-19
C462 a_n3447_n211# a_n3634_765# 3.77e-20
C463 b1 sout2 2.05e-19
C464 b3 a_n2911_2506# 0.073347f
C465 a_n3447_1366# b2 0.010473f
C466 a_n3317_4863# a_n3634_5453# 8.28e-19
C467 a_n1027_2099# b4 1.93e-19
C468 a_n3447_2908# a_n3634_2342# 6.03e-19
C469 sout5 a_n3447_3723# 0.031223f
C470 a_n1749_4456# a_n1749_5210# 6.57e-19
C471 a2 a_n1749_1311# 0.065929f
C472 a_n1749_522# a_n1730_850# 0.00772f
C473 a_n3634_5453# b5 1.33e-19
C474 a_n1008_2427# a_n2911_2506# 4.52e-22
C475 a_n3634_4699# a7 0.010185f
C476 sout1 a_n3317_929# 0.018476f
C477 a6 a_n1730_3996# 4.38e-19
C478 b3 a_n2911_2909# 7.03e-19
C479 a_n3317_1366# b2 0.002741f
C480 b6 a_n1730_3996# 1.75e-19
C481 cin0 a1 0.006551f
C482 sout0 a_n3634_765# 0.087701f
C483 a_n3447_3260# b4 0.004422f
C484 a1 a_n3317_141# 1.04e-19
C485 a_n3634_765# a_n3447_141# 7.67e-19
C486 a5 a_n3634_4699# 0.638273f
C487 a_n1749_2099# sout3 8.56e-21
C488 a_n3317_2908# a_n3634_3096# 0.001568f
C489 a_n3447_1366# a_n3447_929# 0.002266f
C490 a_n3317_4863# VDD 0.029633f
C491 a_n1027_1311# a_n3634_765# 0.030706f
C492 sout1 b2 0.001864f
C493 a_n3447_5265# cout7 3.77e-20
C494 a_n3634_3096# a_n3447_2506# 8.28e-19
C495 a_n3634_5453# a_n3447_4511# 3.77e-20
C496 a_n3317_4511# a_n3634_4699# 0.001568f
C497 b4 a_n3634_2342# 0.003529f
C498 a_n3317_5265# cout7 4.61e-20
C499 a_n1730_1639# a_n3634_2342# 0.125919f
C500 VDD b5 1.01764f
C501 a_n1027_n266# a_n3634_765# 0.100537f
C502 a_n1749_522# sout1 8.56e-21
C503 b2 a_n2911_1718# 0.073347f
C504 a_n2911_4075# b5 0.073347f
C505 a_n2911_4863# a6 0.074154f
C506 a_n1027_2853# a_n1749_2853# 0.019488f
C507 a_n1749_522# a_n2911_578# 1.46e-19
C508 a_n2911_4863# b6 0.073347f
C509 VDD a_n1027_2853# 0.033385f
C510 a_n3634_3096# sout3 0.088013f
C511 a5 a4 0.035972f
C512 sout5 a_n1730_3996# 7.26e-20
C513 sout1 a0 5.56e-19
C514 a_n2911_578# a0 7.59e-19
C515 a_n1027_522# a2 1.76e-19
C516 a_n1749_3668# a5 0.065929f
C517 b1 a_n3447_577# 0.010473f
C518 sout4 a_n1730_3181# 7.26e-20
C519 a3 a_n1027_2853# 0.003484f
C520 sout2 a_n3634_1554# 0.111002f
C521 b5 a_n1008_3996# 0.201653f
C522 a1 a_n1730_850# 0.033659f
C523 a_n3447_1718# a_n3634_1554# 0.003618f
C524 a_n3634_3096# a_n3634_3911# 0.546216f
C525 a_n3317_5617# sout7 0.018476f
C526 b1 a_n3634_1554# 0.904028f
C527 a_n3634_5453# sout7 0.111015f
C528 a_n3447_2154# a_n3634_3096# 3.77e-20
C529 a_n3317_n211# a0 0.001953f
C530 a_n1027_3668# a_n3634_4699# 0.100409f
C531 a_n3447_2908# VDD 0.00106f
C532 a_n3634_765# b0 0.904909f
C533 a_n2911_2155# sout3 0.041347f
C534 sout0 a_n1730_62# 7.26e-20
C535 a_n3317_3260# a4 0.001237f
C536 sout1 a_n3447_929# 0.036174f
C537 a_n3447_4511# VDD 9.21e-19
C538 b3 a2 3.06e-20
C539 a_n2911_5617# sout7 0.034167f
C540 a_n1749_4456# a6 0.065929f
C541 a_n1749_4456# b6 0.036154f
C542 a_n2911_929# a_n3634_765# 0.019818f
C543 a_n1027_522# a_n1008_850# 0.009429f
C544 a_n3447_5265# b7 0.010473f
C545 a_n3317_3723# VDD 9.23e-19
C546 a_n3447_5617# b7 0.004422f
C547 a_n3447_3723# a_n3634_3911# 0.002776f
C548 a_n1027_3668# a4 0.002992f
C549 a_n3317_4075# b5 0.004341f
C550 a_n3317_5265# b7 0.002741f
C551 a_n1749_3668# a_n1027_3668# 0.019488f
C552 sout1 a1 0.119864f
C553 a_n1027_1311# a_n1749_1311# 0.019488f
C554 a_n3447_1366# a_n3634_2342# 3.77e-20
C555 a1 a_n2911_578# 0.045558f
C556 sout7 VDD 0.155231f
C557 b4 a_n1749_2853# 0.036154f
C558 sout2 a_n3317_929# 2.04e-19
C559 b4 VDD 1.02195f
C560 a_n2911_5266# a7 0.045558f
C561 a_n1730_1639# VDD 0.361997f
C562 b4 a3 3.42e-20
C563 a_n2911_4863# cout7 1.57e-20
C564 a_n1008_62# a0 0.169292f
C565 a_n3634_5453# a_n3447_4863# 8.28e-19
C566 a_n1730_1639# a3 4.38e-19
C567 b1 a_n3317_929# 0.004341f
C568 a_n3634_1554# a_n3447_577# 3.77e-20
C569 a_n1730_62# b0 0.26536f
C570 a_n3317_1366# a_n3634_2342# 4.61e-20
C571 a_n1027_5210# a_n3634_4699# 0.046544f
C572 a5 a_n1730_3181# 3.97e-19
C573 cin0 VDD 0.954111f
C574 sout2 b2 0.16871f
C575 a_n1749_522# a_n1749_n266# 6.28e-19
C576 a_n1027_2099# a4 1.95e-19
C577 VDD a_n3317_141# 0.029633f
C578 a_n1749_4456# a_n2911_4512# 1.46e-19
C579 a_n3447_1718# b2 0.004422f
C580 sout3 a_n1730_2427# 7.26e-20
C581 a_n1749_5210# sout7 8.56e-21
C582 a_n2911_2909# a_n1027_2853# 7.89e-21
C583 a_n1749_4456# a_n1027_4456# 0.019488f
C584 a_n1749_n266# a0 0.065929f
C585 b1 b2 0.021122f
C586 VDD a_n1008_3181# 0.627796f
C587 sout1 a_n3634_2342# 0.003066f
C588 a_n1730_3996# a_n3634_3911# 0.056654f
C589 a_n3447_5265# sout6 5.62e-19
C590 a_n3317_4863# a6 0.001237f
C591 a_n3317_4863# b6 0.004341f
C592 a_n1730_1639# a_n1008_1639# 0.032245f
C593 b3 a_n3447_2506# 0.004422f
C594 VDD a_n3447_4863# 0.01215f
C595 a_n1027_522# a_n1027_1311# 0.004706f
C596 b1 a_n1749_522# 0.036154f
C597 a_n3317_5265# sout6 5.62e-19
C598 a_n3634_2342# a_n2911_1718# 0.007995f
C599 a_n1008_3181# a_n1008_3996# 3e-19
C600 a6 b5 8.04e-19
C601 b1 a0 3.06e-20
C602 b6 b5 0.021185f
C603 a_n1749_2099# a_n3634_3096# 0.150082f
C604 a_n1008_62# a1 2.72e-19
C605 a_n2911_3724# a5 0.045558f
C606 b3 sout3 0.16871f
C607 a_n3317_2908# a_n3317_2506# 0.002491f
C608 a_n1027_522# a_n1027_n266# 0.004712f
C609 a_n2911_4863# b7 5.06e-19
C610 VDD a_n1730_850# 0.361997f
C611 sout2 a_n3447_929# 1.44e-19
C612 a_n3447_1366# VDD 9.18e-19
C613 a_n3447_2506# a_n3317_2506# 0.014951f
C614 b4 a_n2911_2506# 5.06e-19
C615 b3 a_n3634_3911# 1.53e-19
C616 a_n3634_2342# a4 0.010185f
C617 b3 a_n1027_1311# 1.74e-19
C618 a_n3447_2154# b3 0.010473f
C619 b1 a_n3447_929# 0.004422f
C620 a_n2911_3260# b5 4.03e-19
C621 a_n1749_2099# a_n2911_2155# 1.46e-19
C622 a_n3317_929# a_n3634_1554# 7.65e-19
C623 a_n3634_5453# a_n3634_4699# 0.568869f
C624 a_n3634_765# a_n1730_62# 0.125919f
C625 sout4 a5 0.004392f
C626 a1 a_n1749_n266# 9.55e-20
C627 sout3 a_n3317_2506# 0.018476f
C628 sout7 a_n1730_5538# 7.26e-20
C629 a_n1027_522# b0 0.008248f
C630 b6 a_n3447_4511# 0.010473f
C631 a_n3317_1366# VDD 0.00101f
C632 a_n1730_4784# a_n3634_4699# 0.056654f
C633 cin0 a_n2911_141# 0.019818f
C634 b4 a_n2911_2909# 0.007386f
C635 a_n3634_765# a_n1749_1311# 0.077605f
C636 sout2 a1 5.55e-19
C637 sout5 b5 0.16871f
C638 a_n1749_2099# a_n1749_1311# 6.28e-19
C639 a_n3634_3096# a_n2911_2155# 0.132214f
C640 sout4 a_n3317_3260# 0.018476f
C641 a_n2911_3724# a_n1027_3668# 7.89e-21
C642 a_n3634_1554# b2 0.614483f
C643 b1 a1 1.02288f
C644 a_n2911_4512# b5 6.54e-19
C645 sout1 VDD 0.154717f
C646 a_n1749_4456# a_n3634_3911# 0.07824f
C647 VDD a_n2911_578# 0.003014f
C648 a_n1027_4456# b5 0.008248f
C649 a_n3634_3096# a_n3447_3723# 5.27e-19
C650 a6 sout7 5.92e-19
C651 a_n1749_522# a_n3634_1554# 0.150082f
C652 b6 sout7 2.28e-19
C653 VDD a_n3634_4699# 1.39939f
C654 a_n2911_4863# a_n1008_4784# 4.52e-22
C655 a_n2911_4075# a_n3634_4699# 0.007995f
C656 a_n2911_5266# a_n1027_5210# 7.89e-21
C657 VDD a_n2911_1718# 0.142768f
C658 a_n3634_1554# a0 6.34e-19
C659 a_n3317_n211# VDD 1.94e-19
C660 a_n2911_4863# sout6 0.034167f
C661 a3 a_n2911_1718# 0.006839f
C662 sout5 a_n3447_4511# 4.97e-19
C663 sout2 a_n3317_2154# 4.97e-19
C664 a_n3634_4699# a_n1008_3996# 0.132333f
C665 sout2 a_n3634_2342# 0.087701f
C666 a_n1749_2853# a4 0.065929f
C667 a_n3447_1718# a_n3634_2342# 7.67e-19
C668 a_n3634_1554# a_n3447_929# 7.65e-19
C669 VDD a4 0.604692f
C670 a_n1749_3668# a_n1749_2853# 6.07e-19
C671 a_n1749_2099# a_n1730_2427# 0.00772f
C672 b4 a_n2911_3260# 0.073347f
C673 a_n1749_3668# VDD 0.024828f
C674 a_n3317_3723# sout5 0.01501f
C675 b1 a_n3634_2342# 1.32e-19
C676 a3 a4 0.041427f
C677 a_n1027_522# a_n3634_765# 0.070949f
C678 a_n1749_5210# a_n3634_4699# 0.1096f
C679 cin0 a_n3317_577# 5.59e-19
C680 a_n1749_4456# sout6 8.56e-21
C681 a_n3317_577# a_n3317_141# 0.002272f
C682 a_n1730_1639# a2 0.033659f
C683 a_n1008_1639# a_n2911_1718# 4.52e-22
C684 sout5 b4 1.91e-19
C685 b6 a_n3447_4863# 0.004422f
C686 a_n3634_3096# a_n1730_2427# 0.126176f
C687 a_n3317_3260# a5 9.53e-20
C688 a_n3634_1554# a1 0.638268f
C689 a_n3317_4075# a_n3634_4699# 7.67e-19
C690 a_n1027_2099# a_n3634_1554# 0.031007f
C691 a_n1008_62# VDD 0.618613f
C692 b3 a_n1749_2099# 0.036154f
C693 a_n1008_3181# a_n2911_3260# 4.52e-22
C694 a_n3317_5265# a_n3447_5265# 0.014951f
C695 cout7 sout7 0.084543f
C696 a_n2911_141# a_n2911_578# 0.006752f
C697 a_n2911_5266# a_n3634_5453# 0.012035f
C698 a_n1008_5538# a7 0.169292f
C699 a_n3447_2908# a_n3317_2908# 0.014951f
C700 sout4 a_n3447_3260# 0.036174f
C701 b5 a_n3634_3911# 0.614462f
C702 a_n3447_2908# a_n3447_2506# 0.002491f
C703 a_n1027_3668# a5 0.148957f
C704 a_n3317_929# a_n3447_929# 0.014951f
C705 VDD a_n1749_n266# 0.022884f
C706 a_n1027_2853# a_n3634_3911# 0.100409f
C707 b3 a_n3634_3096# 0.904296f
C708 a_n3317_2154# a_n3634_1554# 5.59e-19
C709 sout4 a_n3634_2342# 0.002135f
C710 a_n3447_2908# sout3 5.62e-19
C711 sout2 VDD 0.154701f
C712 a4 a_n2911_2506# 0.007303f
C713 cin0 a_n2911_n210# 0.012035f
C714 a_n1749_2853# a_n1730_3181# 0.00772f
C715 a_n3634_1554# a_n3634_2342# 0.554879f
C716 a_n3447_1718# VDD 0.01215f
C717 a_n1749_522# a0 6.66e-19
C718 sout2 a3 0.004592f
C719 a_n3634_3096# a_n1008_2427# 0.132417f
C720 VDD a_n1730_3181# 0.361997f
C721 a_n3447_2908# a_n3634_3911# 3.77e-20
C722 b3 a_n2911_2155# 0.007386f
C723 b1 VDD 1.0193f
C724 a2 a_n1730_850# 4.36e-19
C725 a_n3447_929# b2 2.39e-19
C726 a_n2911_5266# VDD 0.003504f
C727 a_n3447_4511# a_n3634_3911# 5.59e-19
C728 a_n3634_3096# a_n3317_2506# 8.28e-19
C729 a_n3317_929# a1 0.001237f
C730 a_n3317_4863# sout6 0.018476f
C731 a_n3317_2908# b4 0.002741f
C732 a_n2911_2909# a4 0.045558f
C733 a_n1027_5210# a7 0.148957f
C734 cin0 a_n3447_n211# 0.002776f
C735 a6 a_n3634_4699# 0.228873f
C736 sout6 b5 2.06e-19
C737 b4 a_n3447_2506# 2.68e-19
C738 b6 a_n3634_4699# 0.614484f
C739 sout7 b7 0.16871f
C740 a_n3317_3723# a_n3634_3911# 0.001568f
C741 a_n3317_1366# a2 0.001953f
C742 sout1 a_n3317_577# 0.01501f
C743 a_n1008_62# a_n2911_141# 4.52e-22
C744 a1 b2 3.06e-20
C745 a_n1027_2099# b2 0.008248f
C746 b4 sout3 0.002016f
C747 a_n1008_850# a_n1730_850# 0.032245f
C748 a_n2911_5266# a_n1749_5210# 1.46e-19
C749 b4 a_n3634_3911# 0.903818f
C750 a_n3634_4699# a_n2911_3260# 1.28e-20
C751 cin0 sout0 0.110878f
C752 a_n2911_3724# VDD 0.002691f
C753 a_n1749_522# a1 0.065929f
C754 sout1 a2 0.004584f
C755 a_n1749_3668# a6 9.55e-20
C756 cin0 a_n3447_141# 0.003618f
C757 a_n3447_4511# sout6 0.031223f
C758 sout0 a_n3317_141# 0.018476f
C759 a1 a0 0.038139f
C760 a_n3447_141# a_n3317_141# 0.014951f
C761 a2 a_n2911_1718# 0.074154f
C762 sout4 a_n1749_2853# 8.56e-21
C763 VDD a_n3447_577# 9.21e-19
C764 sout5 a_n3634_4699# 0.087701f
C765 a_n3447_3260# a_n3317_3260# 0.014951f
C766 sout4 VDD 0.155326f
C767 sout4 a3 5.92e-19
C768 a4 a_n2911_3260# 0.074154f
C769 a_n3634_1554# VDD 1.39988f
C770 b3 a_n1730_2427# 0.26536f
C771 a_n3447_4863# b7 2.68e-19
C772 VDD a_n3447_4075# 0.01215f
C773 a_n3317_5617# a7 0.001237f
C774 cin0 a_n1027_n266# 0.032457f
C775 b1 a_n2911_141# 4.44e-19
C776 a_n3634_4699# a_n2911_4512# 0.012035f
C777 a_n3634_1554# a3 0.008974f
C778 a_n3634_2342# b2 0.904036f
C779 a_n3634_5453# a7 0.226585f
C780 a_n1008_3181# a_n3634_3911# 0.132272f
C781 a_n1027_4456# a_n3634_4699# 0.070949f
C782 sout7 sout6 0.012655f
C783 a_n1008_2427# a_n1730_2427# 0.032245f
C784 cout7 a_n3634_4699# 0.022241f
C785 a_n1730_4784# a7 4.99e-19
C786 a_n1027_5210# a_n1008_5538# 0.009429f
C787 sout5 a4 5.31e-19
C788 a_n2911_5617# a7 0.074154f
C789 a_n1749_3668# sout5 8.56e-21
C790 a_n3634_5453# a5 6.34e-19
C791 cin0 b0 0.453733f
C792 a_n3634_3096# b5 0.002666f
C793 b0 a_n3317_141# 0.004341f
C794 a_n3634_5453# a_n3317_4511# 4.61e-20
C795 a_n3634_1554# a_n1008_1639# 0.041476f
C796 a_n1749_4456# a_n1730_3996# 0.004828f
C797 a_n3634_3096# a_n1027_2853# 0.080167f
C798 VDD a7 0.613943f
C799 b3 a_n1008_2427# 0.201653f
C800 a_n3447_n211# a_n3317_n211# 0.014951f
C801 a_n3317_929# VDD 0.029633f
C802 a_n2911_5266# a6 8.16e-19
C803 b3 a_n3317_2506# 0.004341f
C804 a_n2911_5266# b6 7.03e-19
C805 a_n3317_4075# a_n3447_4075# 0.014951f
C806 a_n3447_2908# a_n3634_3096# 0.002776f
C807 a5 a_n1749_2853# 8.84e-20
C808 sout1 sout0 0.01176f
C809 a_n3447_4863# sout6 0.036174f
C810 a5 VDD 0.597408f
C811 b1 a_n3317_577# 0.002741f
C812 sout2 a_n2911_1367# 0.041347f
C813 a_n3447_3723# b5 0.010473f
C814 a_n2911_4075# a5 0.074154f
C815 a_n3634_4699# b7 0.003529f
C816 sout1 a_n3447_141# 1.45e-19
C817 a_n2911_3260# a_n1730_3181# 1.25e-19
C818 a_n2911_141# a_n3634_1554# 1.4e-20
C819 b1 a_n2911_1367# 6.53e-19
C820 a_n1008_62# a_n1008_850# 3.13e-19
C821 a_n3317_4511# VDD 0.001014f
C822 a1 a_n3634_2342# 6.32e-19
C823 a_n1027_2099# a_n3634_2342# 0.070949f
C824 a_n3317_4863# a_n3317_5265# 0.002491f
C825 sout0 a_n3317_n211# 0.01501f
C826 VDD b2 1.01923f
C827 sout2 a2 0.119864f
C828 a5 a_n1008_3996# 0.169292f
C829 a_n1749_5210# a7 0.065929f
C830 a_n3634_5453# a_n1008_5538# 0.041609f
C831 a_n3317_2908# a4 0.001953f
C832 sout4 a_n2911_2909# 0.041347f
C833 a3 b2 8.04e-19
C834 a_n1749_2099# a_n1730_1639# 0.004828f
C835 a_n3317_3260# VDD 0.029633f
C836 a_n3634_3096# a_n3317_3723# 5.27e-19
C837 b1 a2 8.02e-19
C838 a_n3634_4699# a_n3634_3911# 0.554501f
C839 a_n2911_929# a_n1730_850# 1.25e-19
C840 cin0 a_n3634_765# 0.41802f
C841 a_n1749_522# VDD 0.02507f
C842 a_n2911_5617# a_n1008_5538# 4.52e-22
C843 VDD a0 0.56653f
C844 a_n3634_765# a_n3317_141# 7.67e-19
C845 a_n3634_3096# b4 0.613145f
C846 a_n2911_n210# a_n1749_n266# 1.46e-19
C847 sout3 a4 0.004871f
C848 a_n1027_3668# VDD 0.028357f
C849 a_n3317_2154# a_n3634_2342# 0.001568f
C850 a4 a_n3634_3911# 0.638144f
C851 a_n1749_3668# a_n3634_3911# 0.01644f
C852 a_n2911_3724# a_n2911_3260# 0.006297f
C853 sout1 b0 2.06e-19
C854 a_n3317_3723# a_n3447_3723# 0.014951f
C855 b2 a_n1008_1639# 0.201653f
C856 VDD a_n1008_5538# 0.635912f
C857 a5 a_n3317_4075# 0.001237f
C858 a_n2911_578# b0 6.54e-19
C859 a_n3447_929# VDD 0.01215f
C860 b1 a_n1008_850# 0.201653f
C861 sout2 a_n3317_1718# 0.018476f
C862 a_n1730_3996# b5 0.26536f
C863 a_n1027_3668# a_n1008_3996# 0.009429f
C864 a_n2911_5266# cout7 0.132214f
C865 a_n3447_1718# a_n3317_1718# 0.014951f
C866 b6 a_n3447_4075# 2.4e-19
C867 a_n3634_5453# a_n1027_5210# 0.080677f
C868 a_n3317_577# a_n3447_577# 0.014951f
C869 a_n1008_4784# a_n3634_4699# 0.041476f
C870 a_n3317_n211# b0 0.002741f
C871 a_n3317_4075# a_n3317_4511# 0.002272f
C872 sout1 a_n2911_929# 0.034167f
C873 a_n3634_4699# sout6 0.111002f
C874 a_n2911_3724# sout5 0.041347f
C875 a_n1730_5538# a7 0.033659f
C876 a_n3634_1554# a_n3317_577# 4.61e-20
C877 b4 a_n3447_3723# 4.91e-20
C878 sout4 a_n2911_3260# 0.034167f
C879 a_n3634_765# a_n1730_850# 0.056654f
C880 a_n3634_3096# a_n1008_3181# 0.041609f
C881 a_n3447_1366# a_n3634_765# 5.58e-19
C882 a_n3447_5265# sout7 0.031223f
C883 a_n3634_1554# a_n2911_1367# 0.012035f
C884 cin0 a_n1730_62# 0.025174f
C885 a_n3447_5617# sout7 0.036174f
C886 a_n1730_1639# a_n1749_1311# 0.00772f
C887 a1 VDD 0.600264f
C888 a_n1027_2099# VDD 0.030343f
C889 a_n3317_5265# sout7 0.01501f
C890 sout0 a_n1749_n266# 8.56e-21
C891 a_n1027_2099# a3 0.148957f
C892 a_n3634_1554# a2 0.228872f
C893 sout4 sout5 0.011139f
C894 a_n1008_62# a_n1027_n266# 0.009429f
C895 a_n3317_1366# a_n3634_765# 5.58e-19
C896 b3 a_n1027_2853# 0.008812f
C897 a6 a7 0.041427f
C898 VDD a_n1027_5210# 0.03928f
C899 sout5 a_n3447_4075# 0.036174f
C900 b6 a7 9.03e-19
C901 a_n2911_141# a0 0.074154f
C902 a_n3447_3260# VDD 0.01215f
C903 b1 sout0 0.001868f
C904 sout2 sout3 0.01176f
C905 a_n3447_1718# sout3 1.45e-19
C906 a_n2911_5266# b7 0.007386f
C907 a_n1008_2427# a_n1027_2853# 0.017037f
C908 a_n3447_2908# b3 6.01e-20
C909 sout1 a_n3634_765# 0.111002f
C910 a_n1027_n266# a_n1749_n266# 0.019488f
C911 a_n1008_62# b0 0.201653f
C912 b1 a_n3447_141# 2.4e-19
C913 a5 a6 0.038139f
C914 a_n3317_2154# VDD 0.001014f
C915 a_n2911_578# a_n3634_765# 0.012035f
C916 a_n3317_5617# a_n3634_5453# 0.002421f
C917 b6 a5 3.06e-20
C918 a_n1027_2099# a_n1008_1639# 0.015383f
C919 a_n3317_2154# a3 0.001953f
C920 a_n1730_3181# a_n3634_3911# 0.125729f
C921 sout2 a_n3447_2154# 4.97e-19
C922 a_n3634_2342# a_n1749_2853# 0.1096f
C923 a_n3634_1554# a_n1008_850# 0.132331f
C924 b4 a_n1730_2427# 2.04e-19
C925 a_n3447_2154# a_n3447_1718# 0.002272f
C926 b1 a_n1027_1311# 0.008232f
C927 VDD a_n3634_2342# 1.4001f
C928 a_n3447_5265# a_n3447_4863# 0.002491f
C929 a_n1749_4456# b5 4.89e-19
C930 a_n3317_4511# a6 0.001953f
C931 a3 a_n3634_2342# 0.228873f
C932 a_n3317_n211# a_n3634_765# 4.61e-20
C933 a_n3634_5453# a_n1730_4784# 0.126176f
C934 a_n3634_1554# a_n3317_1718# 0.002421f
C935 b6 a_n3317_4511# 0.002741f
C936 a_n1749_5210# a_n1027_5210# 0.019488f
C937 a_n3634_5453# a_n2911_5617# 0.019818f
C938 b1 a_n1027_n266# 1.74e-19
C939 a_n1749_n266# b0 0.036154f
C940 a_n1749_1311# a_n1730_850# 0.004814f
C941 a5 a_n2911_3260# 0.00651f
C942 a_n1730_5538# a_n1008_5538# 0.032245f
C943 a_n3317_929# a2 1.03e-19
C944 cin0 a_n1027_522# 0.030701f
C945 a_n3634_3096# a_n3634_4699# 0.017875f
C946 a_n2911_141# a1 0.006839f
C947 a_n1749_2099# a4 1.06e-19
C948 sout4 a_n3317_2908# 0.01501f
C949 a_n2911_1367# b2 0.007386f
C950 a_n3317_5617# VDD 0.029633f
C951 b3 b4 0.023614f
C952 a_n3634_3096# a_n2911_1718# 1.4e-20
C953 a_n1027_4456# a7 1.95e-19
C954 b3 a_n1730_1639# 1.75e-19
C955 a_n3634_5453# VDD 1.42388f
C956 a_n1027_3668# a6 1.76e-19
C957 a5 sout5 0.119864f
C958 a_n1749_522# a_n3317_577# 8.29e-21
C959 sout4 a_n3447_2506# 1.59e-19
C960 b6 a_n1027_3668# 1.74e-19
C961 b1 b0 0.021185f
C962 a_n3317_1366# a_n1749_1311# 8.29e-21
C963 a_n2911_3724# a_n3634_3911# 0.012035f
C964 a_n3634_2342# a_n1008_1639# 0.132333f
C965 a_n2911_4075# a_n3634_5453# 1.4e-20
C966 cout7 a7 0.636064f
C967 sout0 a_n3447_577# 4.97e-19
C968 a_n1730_4784# VDD 0.361997f
C969 a2 b2 1.02288f
C970 a_n1008_2427# b4 7.93e-20
C971 sout5 a_n3317_4511# 4.97e-19
C972 a_n2911_5617# VDD 0.142768f
C973 a5 a_n2911_4512# 7.59e-19
C974 a_n3447_141# a_n3447_577# 0.002272f
C975 a_n2911_2155# a_n2911_1718# 0.006752f
C976 a_n3634_1554# sout0 0.003071f
C977 sout4 sout3 0.012655f
C978 a_n3634_3096# a4 0.226232f
C979 a5 a_n1027_4456# 0.003191f
C980 b1 a_n2911_929# 0.073347f
C981 a_n3317_3260# sout5 1.9e-19
C982 a_n1749_3668# a_n3634_3096# 0.064247f
C983 a_n1008_62# a_n3634_765# 0.132333f
C984 a_n1749_522# a2 9.52e-20
C985 a_n3634_1554# sout3 0.001929f
C986 a_n3447_3723# a_n3634_4699# 3.77e-20
C987 sout4 a_n3634_3911# 0.087482f
C988 a_n3634_1554# a_n1027_1311# 0.070763f
C989 a_n3634_2342# a_n2911_2506# 0.019818f
C990 a_n3634_5453# a_n1749_5210# 0.016361f
C991 VDD a_n1749_2853# 0.025442f
C992 a_n3447_4075# a_n3634_3911# 0.003618f
C993 a_n3447_5265# a_n3634_4699# 6.03e-19
C994 a_n3447_2154# a_n3634_1554# 5.59e-19
C995 a3 a_n1749_2853# 7.31e-19
C996 b2 a_n1008_850# 7.05e-20
C997 a3 VDD 0.60027f
C998 a_n3634_765# a_n1749_n266# 0.15071f
C999 a_n2911_4075# VDD 0.142768f
C1000 a_n1730_4784# a_n1749_5210# 0.005351f
C1001 a_n1008_2427# a_n1008_3181# 3.29e-19
C1002 a_n3317_5265# a_n3634_4699# 6.03e-19
C1003 b2 a_n3317_1718# 0.004341f
C1004 VDD a_n1008_3996# 0.627786f
C1005 a_n2911_2909# a_n3634_2342# 0.001648f
C1006 a_n3317_577# a1 0.001953f
C1007 a6 a_n1027_5210# 0.003484f
C1008 sout2 a_n3634_765# 0.001923f
C1009 a_n1027_2853# b5 1.61e-19
C1010 sout0 GND 0.525447f
C1011 a0 GND 1.80776f
C1012 b0 GND 1.19407f
C1013 cin0 GND 1.78933f
C1014 sout1 GND 0.506031f
C1015 a1 GND 1.72363f
C1016 b1 GND 1.16061f
C1017 sout2 GND 0.506035f
C1018 a2 GND 1.72375f
C1019 b2 GND 1.16066f
C1020 sout3 GND 0.504801f
C1021 a3 GND 1.72054f
C1022 b3 GND 1.15824f
C1023 sout4 GND 0.50553f
C1024 a4 GND 1.71799f
C1025 b4 GND 1.15769f
C1026 sout5 GND 0.506987f
C1027 a5 GND 1.72869f
C1028 b5 GND 1.16334f
C1029 sout6 GND 0.504801f
C1030 a6 GND 1.72044f
C1031 b6 GND 1.15824f
C1032 sout7 GND 0.53061f
C1033 cout7 GND 1.10073f
C1034 a7 GND 1.71991f
C1035 b7 GND 1.18454f
C1036 VDD GND 38.523304f
C1037 a_n1027_n266# GND 0.594926f
C1038 a_n1749_n266# GND 0.369592f
C1039 a_n2911_n210# GND 0.266617f
C1040 a_n3317_n211# GND 0.034564f
C1041 a_n3447_n211# GND 0.015853f
C1042 a_n1008_62# GND 0.080444f
C1043 a_n1730_62# GND 0.019295f
C1044 a_n2911_141# GND 0.029159f
C1045 a_n3317_141# GND 0.005769f
C1046 a_n3447_141# GND 0.005769f
C1047 a_n1027_522# GND 0.502641f
C1048 a_n1749_522# GND 0.301881f
C1049 a_n2911_578# GND 0.255365f
C1050 a_n3317_577# GND 0.031205f
C1051 a_n3447_577# GND 0.012494f
C1052 a_n1008_850# GND 0.08001f
C1053 a_n1730_850# GND 0.019302f
C1054 a_n2911_929# GND 0.029181f
C1055 a_n3317_929# GND 0.005773f
C1056 a_n3447_929# GND 0.005773f
C1057 a_n3634_765# GND 3.16016f
C1058 a_n1027_1311# GND 0.502859f
C1059 a_n1749_1311# GND 0.302052f
C1060 a_n2911_1367# GND 0.25539f
C1061 a_n3317_1366# GND 0.031213f
C1062 a_n3447_1366# GND 0.012502f
C1063 a_n1008_1639# GND 0.079985f
C1064 a_n1730_1639# GND 0.019295f
C1065 a_n2911_1718# GND 0.029159f
C1066 a_n3317_1718# GND 0.005769f
C1067 a_n3447_1718# GND 0.005769f
C1068 a_n3634_1554# GND 3.04745f
C1069 a_n1027_2099# GND 0.502335f
C1070 a_n1749_2099# GND 0.301832f
C1071 a_n2911_2155# GND 0.255365f
C1072 a_n3317_2154# GND 0.031205f
C1073 a_n3447_2154# GND 0.012494f
C1074 a_n1008_2427# GND 0.079084f
C1075 a_n1730_2427# GND 0.019017f
C1076 a_n2911_2506# GND 0.028401f
C1077 a_n3317_2506# GND 0.005645f
C1078 a_n3447_2506# GND 0.005645f
C1079 a_n3634_2342# GND 3.10362f
C1080 a_n1027_2853# GND 0.494768f
C1081 a_n1749_2853# GND 0.295821f
C1082 a_n2911_2909# GND 0.254429f
C1083 a_n3317_2908# GND 0.030923f
C1084 a_n3447_2908# GND 0.012212f
C1085 a_n1008_3181# GND 0.08064f
C1086 a_n1730_3181# GND 0.019504f
C1087 a_n2911_3260# GND 0.029741f
C1088 a_n3317_3260# GND 0.005868f
C1089 a_n3447_3260# GND 0.005868f
C1090 a_n3634_3096# GND 3.00165f
C1091 a_n1027_3668# GND 0.508501f
C1092 a_n1749_3668# GND 0.306361f
C1093 a_n2911_3724# GND 0.256028f
C1094 a_n3317_3723# GND 0.031405f
C1095 a_n3447_3723# GND 0.012694f
C1096 a_n1008_3996# GND 0.080002f
C1097 a_n1730_3996# GND 0.019295f
C1098 a_n2911_4075# GND 0.029159f
C1099 a_n3317_4075# GND 0.005769f
C1100 a_n3447_4075# GND 0.005769f
C1101 a_n3634_3911# GND 3.06392f
C1102 a_n1027_4456# GND 0.502335f
C1103 a_n1749_4456# GND 0.301832f
C1104 a_n2911_4512# GND 0.255365f
C1105 a_n3317_4511# GND 0.031205f
C1106 a_n3447_4511# GND 0.012494f
C1107 a_n1008_4784# GND 0.079084f
C1108 a_n1730_4784# GND 0.019017f
C1109 a_n2911_4863# GND 0.028401f
C1110 a_n3317_4863# GND 0.005645f
C1111 a_n3447_4863# GND 0.005645f
C1112 a_n3634_4699# GND 3.10568f
C1113 a_n1027_5210# GND 0.488314f
C1114 a_n1749_5210# GND 0.296769f
C1115 a_n2911_5266# GND 0.254429f
C1116 a_n3317_5265# GND 0.030923f
C1117 a_n3447_5265# GND 0.012212f
C1118 a_n1008_5538# GND 0.062447f
C1119 a_n1730_5538# GND 0.022886f
C1120 a_n2911_5617# GND 0.044307f
C1121 a_n3317_5617# GND 0.008258f
C1122 a_n3447_5617# GND 0.008258f
C1123 a_n3634_5453# GND 3.28791f
.ends
