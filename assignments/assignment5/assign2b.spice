** sch_path: /home/joyen/ee5311/EE5311/assignments/assignment5/assign2b.sch
**.subckt assign2b
x1 VDD vin out VDD VDD GND nand_tb
V3 VDD GND 1.8
V4 vin GND PULSE 0 1.8 50p 5p 5p 400p 1n
**** begin user architecture code
.lib /cad/share/pdk/sky130B/libs.tech/combined/sky130.lib.spice tt

.incldue nand_tb_extracted.spice
.control
tran 0.1p 1n
meas tran tphl trig v(vin) val=0.9 rise=1 targ v(out) val=0.9 fall=1
meas tran tplh trig v(vin) val=0.9 fall=1 targ v(out) val=0.9 rise=1
let tpd = (tphl + tplh) / 2
print tpd

plot v(out) v(vin)
.endc

**** end user architecture code
**.ends
.GLOBAL VDD
.GLOBAL GND
.end
