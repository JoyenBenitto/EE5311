** sch_path: /home/joyen/ee5311/EE5311/tutorials/tutorial_4/inv.sch
.subckt inv out in DGND DVDD
*.PININFO out:O in:I DGND:B DVDD:B
XM2 out in DGND DGND sky130_fd_pr__nfet_01v8 L=0.15 W=0.42 nf=1
XM1 out in DVDD DVDD sky130_fd_pr__pfet_01v8 L=0.15 W=1 nf=1
.ends
