** sch_path: /home/joyen/ee5311/workdir/EE5311/assignments/assignment1/assign2b.sch
**.subckt assign2b
Vdd VDD GND 1.8
XM1 Vds Vin VDD VDD sky130_fd_pr__pfet_01v8 L=0.15 W=0.42 nf=1 ad='int((nf+1)/2) * W/nf * 0.29' as='int((nf+2)/2) * W/nf * 0.29' pd='2*int((nf+1)/2) * (W/nf + 0.29)'
+ ps='2*int((nf+2)/2) * (W/nf + 0.29)' nrd='0.29 / W' nrs='0.29 / W' sa=0 sb=0 sd=0 mult=1
Vin Vin GND 1.8
Vds Vds GND 1.8
**** begin user architecture code

.include sim2b.cir

.lib /cad/share/pdk/sky130B/libs.tech/combined/sky130.lib.spice tt
**** end user architecture code
**.ends
.GLOBAL GND
.GLOBAL VDD
.end
