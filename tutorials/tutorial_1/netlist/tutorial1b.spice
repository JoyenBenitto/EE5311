** sch_path: /home/joyenbenitto/Desktop/projects/EE5311/tutorial_1/tutorial1b.sch
**.subckt tutorial1b
Vdd1 VDD GND 1.8
Vin VDD GND 1.8
XM1 Vdd1 Vin GND GND sky130_fd_pr__nfet_01v8 L=0.15 W=0.42 nf=1 ad=0.1218 as=0.1218 pd=1.42 ps=1.42 nrd=0.69047619047619
+ nrs=0.69047619047619 sa=0 sb=0 sd=0 mult=1
**** begin user architecture code

.control
let Vgs = 0.6
repeat 4
	alter Vin1 $&Vgs
	dc Vdd1 0 1.8 0.02
	let Vgs = Vgs + 0.4
end
plot dc1.I(Vdd1)*-1 dc2I(Vdd1)*-1 dc3.I(vdd1)*-1 dc4.I(Vdd1)*-1
set filetype=ascii
wrdata nmos_ids_vds.txt dc1.I(Vdd1)*-1 dc2.I(Vdd1)*-1 dc3.I(Vdd1)*-1 dc4.I(vdd1)*-1
.endc

**** end user architecture code
**.ends
.GLOBAL GND
.GLOBAL VDD
.end
