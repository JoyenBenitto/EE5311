* NGSPICE file created from sum.ext - technology: sky130A

.subckt sum VDD a b coutbar cin sout GND
X0 GND.t10 a.t0 a_n551_n195# GND.t9 sky130_fd_pr__nfet_01v8 ad=0.126 pd=1.44 as=0.105 ps=0.92 w=0.42 l=0.15
X1 a_n957_n196# b.t0 a_n1087_n196# GND.t7 sky130_fd_pr__nfet_01v8 ad=0.105 pd=0.92 as=0.105 ps=0.92 w=0.42 l=0.15
X2 a_n957_156# b.t1 a_n1087_156# VDD.t7 sky130_fd_pr__pfet_01v8 ad=0.105 pd=0.92 as=0.105 ps=0.92 w=0.42 l=0.15
X3 GND.t1 cin.t0 a_n957_n196# GND.t0 sky130_fd_pr__nfet_01v8 ad=0.126 pd=1.44 as=0.105 ps=0.92 w=0.42 l=0.15
X4 a_n551_n195# coutbar.t0 sout.t0 GND.t2 sky130_fd_pr__nfet_01v8 ad=0.105 pd=0.92 as=0.126 ps=1.44 w=0.42 l=0.15
X5 VDD.t1 cin.t1 a_n957_156# VDD.t0 sky130_fd_pr__pfet_01v8 ad=0.126 pd=1.44 as=0.105 ps=0.92 w=0.42 l=0.15
X6 VDD.t10 a.t1 a_n551_156# VDD.t9 sky130_fd_pr__pfet_01v8 ad=0.126 pd=1.44 as=0.105 ps=0.92 w=0.42 l=0.15
X7 a_n1087_156# a.t2 sout.t3 VDD.t8 sky130_fd_pr__pfet_01v8 ad=0.105 pd=0.92 as=0.126 ps=1.44 w=0.42 l=0.15
X8 a_n551_156# coutbar.t1 sout.t1 VDD.t4 sky130_fd_pr__pfet_01v8 ad=0.105 pd=0.92 as=0.126 ps=1.44 w=0.42 l=0.15
X9 VDD.t3 cin.t2 a_n551_156# VDD.t2 sky130_fd_pr__pfet_01v8 ad=0.105 pd=0.92 as=0.105 ps=0.92 w=0.42 l=0.15
X10 GND.t4 cin.t3 a_n551_n195# GND.t3 sky130_fd_pr__nfet_01v8 ad=0.105 pd=0.92 as=0.105 ps=0.92 w=0.42 l=0.15
X11 a_n551_156# b.t2 VDD.t6 VDD.t5 sky130_fd_pr__pfet_01v8 ad=0.105 pd=0.92 as=0.105 ps=0.92 w=0.42 l=0.15
X12 a_n551_n195# b.t3 GND.t6 GND.t5 sky130_fd_pr__nfet_01v8 ad=0.105 pd=0.92 as=0.105 ps=0.92 w=0.42 l=0.15
X13 a_n1087_n196# a.t3 sout.t2 GND.t8 sky130_fd_pr__nfet_01v8 ad=0.105 pd=0.92 as=0.126 ps=1.44 w=0.42 l=0.15
R0 a.t0 a.t3 1887.83
R1 a.t3 a.t2 633.028
R2 a a.t1 377.567
R3 a a.t0 359.894
R4 GND.n0 GND.t9 4627.63
R5 GND.t2 GND.t0 3121.85
R6 GND.t9 GND.t5 1470.44
R7 GND.t5 GND.t3 1470.44
R8 GND.t3 GND.t2 1470.44
R9 GND.t0 GND.t7 1470.44
R10 GND.t7 GND.t8 1470.44
R11 GND.n0 GND.t10 267.12
R12 GND GND.t1 266.392
R13 GND.n2 GND.n1 225.145
R14 GND.n1 GND.t6 71.4291
R15 GND.n1 GND.t4 71.4291
R16 GND GND.n2 0.348156
R17 GND.n2 GND.n0 0.313
R18 b.n1 b.n0 436.693
R19 b.n0 b.t1 244.214
R20 b.n1 b.t3 242.607
R21 b.n0 b.t0 234.573
R22 b b.t2 223.327
R23 b b.n1 11.2472
R24 VDD.n0 VDD.t9 1171.34
R25 VDD.t4 VDD.t0 1092.5
R26 VDD.n0 VDD.t10 684.235
R27 VDD VDD.t1 684.014
R28 VDD.n2 VDD.n1 614.097
R29 VDD.t9 VDD.t5 514.583
R30 VDD.t5 VDD.t2 514.583
R31 VDD.t2 VDD.t4 514.583
R32 VDD.t0 VDD.t7 514.583
R33 VDD.t7 VDD.t8 514.583
R34 VDD.n1 VDD.t6 117.263
R35 VDD.n1 VDD.t3 117.263
R36 VDD VDD.n2 0.333833
R37 VDD.n2 VDD.n0 0.313
R38 cin.n1 cin.n0 447.644
R39 cin.n0 cin.t1 260.719
R40 cin.n0 cin.t0 257.505
R41 cin.n1 cin.t3 255.899
R42 cin cin.t2 207.261
R43 cin cin.n1 53.4587
R44 coutbar coutbar.t0 335.793
R45 coutbar coutbar.t1 228.148
R46 sout.n0 sout.t3 843.885
R47 sout.n0 sout.t1 709.862
R48 sout.n1 sout.t2 416.762
R49 sout sout.n1 322.745
R50 sout.n1 sout.t0 282.363
R51 sout sout.n0 227.952
C0 cin sout 0.260205f
C1 a a_n1087_156# 0.001237f
C2 a_n957_156# VDD 0.029633f
C3 coutbar VDD 0.057443f
C4 a_n551_n195# VDD 9.99e-19
C5 b a_n957_156# 0.004341f
C6 coutbar b 0.006775f
C7 coutbar a_n551_156# 0.005623f
C8 b a_n551_n195# 0.064434f
C9 a_n551_n195# a_n551_156# 0.01836f
C10 VDD a_n1087_156# 0.01215f
C11 a_n957_n196# a 0.001525f
C12 a_n957_156# sout 0.018476f
C13 coutbar sout 0.052935f
C14 a_n551_n195# sout 0.034454f
C15 a VDD 0.200809f
C16 b a_n1087_156# 0.004422f
C17 a a_n1087_n196# 0.002761f
C18 b a 0.139125f
C19 a_n551_156# a 0.007855f
C20 sout a_n1087_156# 0.035858f
C21 a_n957_n196# a_n1087_n196# 0.014951f
C22 a sout 0.060199f
C23 cin a_n957_156# 0.001237f
C24 VDD a_n1087_n196# 2.89e-19
C25 a_n957_n196# b 0.00453f
C26 coutbar cin 0.082914f
C27 a_n551_n195# cin 0.056859f
C28 b VDD 0.317135f
C29 b a_n1087_n196# 0.004724f
C30 a_n551_156# VDD 0.143019f
C31 a_n957_n196# sout 0.018241f
C32 b a_n551_156# 0.063494f
C33 sout VDD 0.177665f
C34 sout a_n1087_n196# 0.035623f
C35 cin a 0.027978f
C36 b sout 0.138791f
C37 a_n551_156# sout 0.034167f
C38 coutbar a_n551_n195# 0.005742f
C39 a_n957_n196# cin 0.001237f
C40 a_n957_156# a_n1087_156# 0.014951f
C41 cin VDD 0.136302f
C42 a a_n957_156# 8.05e-20
C43 b cin 0.204495f
C44 coutbar a 0.011163f
C45 a_n551_156# cin 0.054436f
C46 a_n551_n195# a 0.013878f
C47 sout GND 0.418791f
C48 coutbar GND 0.135419f
C49 cin GND 0.358013f
C50 b GND 0.57278f
C51 a GND 1.12678f
C52 VDD GND 1.65013f
C53 a_n551_n195# GND 0.177742f
C54 a_n957_n196# GND 0.035665f
C55 a_n1087_n196# GND 0.018189f
C56 a_n551_156# GND 0.044853f
C57 a_n957_156# GND 0.008258f
C58 a_n1087_156# GND 0.008504f
.ends
