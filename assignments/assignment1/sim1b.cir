.control

* Process / device parameters (from Tutorial 1)
let vt_n     = 0.7
let mu_n     = 0.025
let cox_n    = 8.34e-3
let vsat_n   = 8e4
let w_val    = 0.42u
let l_val    = 0.15u
let EsatL    = (vsat_n * l_val) / mu_n

* Vgs values to sweep, one named constant per index (all defined before any
* analysis has run, so they stay globally visible from any later dc<N> plot)
let vgs1 = 0.6
let vgs2 = 1.0
let vgs3 = 1.4
let vgs4 = 1.8

foreach idx 1 2 3 4

  alter Vin = vgs$idx
  dc Vds 0 1.8 0.02

  let vds$idx      = v(net2)
  let ids_sim$idx  = -i(Vds)
  let vgt$idx      = max(0, vgs$idx - vt_n)
  let vdsat$idx    = (vgt$idx * EsatL) / (vgt$idx + EsatL + 1e-12)
  let vmin$idx     = min(vds$idx, vdsat$idx)
  let ids_anal$idx = mu_n * cox_n * (w_val / l_val) * (vgt$idx * vmin$idx - 0.5 * vmin$idx^2)
  let pct_error$idx = abs((ids_sim$idx - ids_anal$idx) / (ids_sim$idx + 1e-12)) * 100

  print mean(pct_error$idx)
end

* Human-readable aliases so the plot/hardcopy legend shows which curve is
* which Vgs, instead of the bare ids_simN/ids_analN/dcN.* vector names.
let Vds_V           = dc1.vds1
let Ids_sim_Vgs0_6V  = dc1.ids_sim1
let Ids_anal_Vgs0_6V = dc1.ids_anal1
let Ids_sim_Vgs1_0V  = dc2.ids_sim2
let Ids_anal_Vgs1_0V = dc2.ids_anal2
let Ids_sim_Vgs1_4V  = dc3.ids_sim3
let Ids_anal_Vgs1_4V = dc3.ids_anal3
let Ids_sim_Vgs1_8V  = dc4.ids_sim4
let Ids_anal_Vgs1_8V = dc4.ids_anal4

plot Ids_sim_Vgs0_6V Ids_anal_Vgs0_6V Ids_sim_Vgs1_0V Ids_anal_Vgs1_0V Ids_sim_Vgs1_4V Ids_anal_Vgs1_4V Ids_sim_Vgs1_8V Ids_anal_Vgs1_8V vs Vds_V

hardcopy assign1b_output_char.ps Ids_sim_Vgs0_6V Ids_anal_Vgs0_6V Ids_sim_Vgs1_0V Ids_anal_Vgs1_0V Ids_sim_Vgs1_4V Ids_anal_Vgs1_4V Ids_sim_Vgs1_8V Ids_anal_Vgs1_8V vs Vds_V

.endc
