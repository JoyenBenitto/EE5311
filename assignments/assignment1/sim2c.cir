.param Width = 0.42
.param Length = 0.15
.dc Vds 1.8 0 -0.01
.control

* Process parameters (pMOS, Tutorial 1). Source/Body are tied to VDD, so
* Vsg = VDD - V(gate). Vin is alter'd to 0 every iteration (right after
* reset, since reset would otherwise restore its netlisted default of
* 1.8V) so Vsg stays fixed at VDD = 1.8V for every size swept below --
* the pMOS mirror of sim1c.cir's hardwired Vgs=VDD gate.
let vt_p   = 0.7
let mu_p   = 0.009
let cox_p  = 8.16e-3
let vsat_p = 3e4
let vsgt   = 1.8 - vt_p

* Pre-allocate result vectors for the Vsdsat-vs-L (and VelSatEffect-vs-L)
* plot. Element-indexed assignment (v[i] = ...) is what survives across
* the dc analyses/plot-context switches in the loop.
let Vsdsat_vs_L       = vector(10)*0
let VsatRatio_vs_L    = vector(10)*0
let VelSatEffect_vs_L = vector(10)*0
let L_vec             = vector(10)*0

let index = 1
set cache = ( )
while index <= 10
    let newW = index * 0.42
    let newL = index * 0.15
    alterparam Width = $&newW
    alterparam Length = $&newL
    reset
    alter Vin = 0
    run

    * newW/newL are bare micron-scale numbers (matching the netlist's own
    * SCALE=1e-6 option); convert to metres for these physics formulas.
    let L_m = newL * 1u
    let W_m = newW * 1u

    * EsatL = L*vsat/mu grows with L, so Vsdsat = Vsgt*EsatL/(Vsgt+EsatL)
    * should climb toward the long-channel value Vsgt as L increases.
    let EsatL       = (vsat_p * L_m) / mu_p
    let vsdsat_pred = (vsgt * EsatL) / (vsgt + EsatL)

    * Ideal long-channel (no velocity saturation) square-law prediction:
    * depends only on W/L, held constant across all 10 sizes.
    let isd_ideal   = 0.5 * mu_p * cox_p * (W_m / L_m) * vsgt * vsgt

    * Actual simulated current at Vsd=1.8V. The sweep runs Vds (the drain
    * node's absolute voltage) from 1.8 down to 0, so Vsd = 1.8 - Vds
    * ascends 0->1.8; the LAST row (index 180) is Vds=0, i.e. Vsd=1.8.
    let isd_sim_max = dc{$&index}.i(Vds)[180]

    * Ratio -> 1 as velocity saturation stops suppressing the current
    * relative to the ideal long-channel prediction.
    let vsat_ratio  = isd_sim_max / isd_ideal

    * Primary metric: fractional shortfall of Vsdsat below the ideal
    * long-channel value Vsgt.
    let velsat_effect = 1 - (vsdsat_pred / vsgt)

    let Vsdsat_vs_L[index-1]       = vsdsat_pred
    let VsatRatio_vs_L[index-1]    = vsat_ratio
    let VelSatEffect_vs_L[index-1] = velsat_effect
    let L_vec[index-1]              = newL

    print newL
    print vsdsat_pred
    print isd_sim_max
    print vsat_ratio
    print velsat_effect

    * Clean, readable legend name: "Nx the base (0.42/0.15) size"
    let Isd_x$&index = dc{$&index}.i(Vds)

    * $cache is read back later from dc10's context, so each entry must be
    * qualified with the plot it was actually defined in.
    set cache = ( $cache dc{$&index}.Isd_x$&index )
    let index = index + 1
end

let Vsd_axis = 1.8 - dc1.v(vds)

* Family of Isd-Vsd curves across all 10 sizes (W/L ratio held constant)
plot $cache vs Vsd_axis xlabel Vsd_V ylabel Isd_A
hardcopy assign2c_iv_family.ps $cache vs Vsd_axis xlabel Vsd_V ylabel Isd_A

* Vsdsat vs L (rises toward the long-channel value Vsgt as L grows)
plot Vsdsat_vs_L vs L_vec xlabel L_um ylabel Vsdsat_V
hardcopy assign2c_vsdsat_vs_L.ps Vsdsat_vs_L vs L_vec xlabel L_um ylabel Vsdsat_V

* PRIMARY plot: velocity-saturation effect vs L -- decreases monotonically
* toward 0 as L grows.
plot VelSatEffect_vs_L vs L_vec xlabel L_um ylabel VelSatEffect
hardcopy assign2c_velsat_effect_vs_L.ps VelSatEffect_vs_L vs L_vec xlabel L_um ylabel VelSatEffect

* Secondary/supporting: ratio of simulated to ideal long-channel current.
plot VsatRatio_vs_L vs L_vec xlabel L_um ylabel Isd_ratio
hardcopy assign2c_vsatratio_vs_L.ps VsatRatio_vs_L vs L_vec xlabel L_um ylabel Isd_ratio

.endc
