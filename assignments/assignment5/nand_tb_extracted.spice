* NGSPICE file created from nand_tb.ext - technology: sky130A

.subckt nand_tb DVDD A out B B1 DGND
X0 out.t11 B.t0 DVDD.t27 DVDD.t26 sky130_fd_pr__pfet_01v8 ad=0.105 pd=0.92 as=0.126 ps=1.44 w=0.42 l=0.15
X1 DVDD.t25 B.t1 out.t10 DVDD.t24 sky130_fd_pr__pfet_01v8 ad=0.126 pd=1.44 as=0.105 ps=0.92 w=0.42 l=0.15
X2 DVDD.t1 A.t0 out.t0 DVDD.t0 sky130_fd_pr__pfet_01v8 ad=0.126 pd=1.44 as=0.105 ps=0.92 w=0.42 l=0.15
X3 DVDD.t23 B.t2 out.t9 DVDD.t22 sky130_fd_pr__pfet_01v8 ad=0.105 pd=0.92 as=0.105 ps=0.92 w=0.42 l=0.15
X4 out.t3 A.t1 DVDD.t9 DVDD.t8 sky130_fd_pr__pfet_01v8 ad=0.105 pd=0.92 as=0.126 ps=1.44 w=0.42 l=0.15
X5 a_n1200_125# A.t2 out.t5 DGND.t23 sky130_fd_pr__nfet_01v8 ad=0.105 pd=0.92 as=0.105 ps=0.92 w=0.42 l=0.15
X6 DVDD.t7 A.t3 out.t1 DVDD.t6 sky130_fd_pr__pfet_01v8 ad=0.105 pd=0.92 as=0.105 ps=0.92 w=0.42 l=0.15
X7 DGND.t15 B.t3 a_n1200_125# DGND.t14 sky130_fd_pr__nfet_01v8 ad=0.105 pd=0.92 as=0.105 ps=0.92 w=0.42 l=0.15
X8 out.t2 A.t4 a_n1200_125# DGND.t22 sky130_fd_pr__nfet_01v8 ad=0.105 pd=0.92 as=0.105 ps=0.92 w=0.42 l=0.15
X9 out.t4 A.t5 DVDD.t11 DVDD.t10 sky130_fd_pr__pfet_01v8 ad=0.105 pd=0.92 as=0.105 ps=0.92 w=0.42 l=0.15
X10 DGND.t13 B.t4 a_n1200_125# DGND.t12 sky130_fd_pr__nfet_01v8 ad=0.105 pd=0.92 as=0.126 ps=1.44 w=0.42 l=0.15
X11 a_n1200_125# B.t5 DGND.t11 DGND.t10 sky130_fd_pr__nfet_01v8 ad=0.105 pd=0.92 as=0.105 ps=0.92 w=0.42 l=0.15
X12 a_n1200_125# A.t6 out.t6 DGND.t21 sky130_fd_pr__nfet_01v8 ad=0.126 pd=1.44 as=0.105 ps=0.92 w=0.42 l=0.15
X13 a_n1200_125# B.t6 DGND.t9 DGND.t8 sky130_fd_pr__nfet_01v8 ad=0.105 pd=0.92 as=0.105 ps=0.92 w=0.42 l=0.15
X14 out.t7 A.t7 a_n1200_125# DGND.t20 sky130_fd_pr__nfet_01v8 ad=0.105 pd=0.92 as=0.105 ps=0.92 w=0.42 l=0.15
X15 DVDD.t31 B1.t0 a_n2549_433# DVDD.t30 sky130_fd_pr__pfet_01v8 ad=0.126 pd=1.44 as=0.105 ps=0.92 w=0.42 l=0.15
X16 a_n2549_433# B1.t1 DVDD.t5 DVDD.t4 sky130_fd_pr__pfet_01v8 ad=0.105 pd=0.92 as=0.126 ps=1.44 w=0.42 l=0.15
X17 DVDD.t13 B1.t2 a_n2549_433# DVDD.t12 sky130_fd_pr__pfet_01v8 ad=0.105 pd=0.92 as=0.105 ps=0.92 w=0.42 l=0.15
X18 a_n2532_125# B1.t3 DGND.t7 DGND.t6 sky130_fd_pr__nfet_01v8 ad=0.105 pd=0.92 as=0.105 ps=0.92 w=0.42 l=0.15
X19 a_n2549_433# B1.t4 DVDD.t3 DVDD.t2 sky130_fd_pr__pfet_01v8 ad=0.105 pd=0.92 as=0.105 ps=0.92 w=0.42 l=0.15
X20 DGND.t1 B1.t5 a_n2532_125# DGND.t0 sky130_fd_pr__nfet_01v8 ad=0.105 pd=0.92 as=0.126 ps=1.44 w=0.42 l=0.15
X21 a_n2532_125# B1.t6 DGND.t3 DGND.t2 sky130_fd_pr__nfet_01v8 ad=0.105 pd=0.92 as=0.105 ps=0.92 w=0.42 l=0.15
X22 DGND.t5 B1.t7 a_n2532_125# DGND.t4 sky130_fd_pr__nfet_01v8 ad=0.105 pd=0.92 as=0.105 ps=0.92 w=0.42 l=0.15
X23 a_n1922_125# out.t12 a_n2532_125# DGND.t19 sky130_fd_pr__nfet_01v8 ad=0.105 pd=0.92 as=0.105 ps=0.92 w=0.42 l=0.15
X24 DVDD.t17 out.t13 a_n2549_433# DVDD.t16 sky130_fd_pr__pfet_01v8 ad=0.105 pd=0.92 as=0.105 ps=0.92 w=0.42 l=0.15
X25 a_n2532_125# out.t14 a_n1922_125# DGND.t18 sky130_fd_pr__nfet_01v8 ad=0.126 pd=1.44 as=0.105 ps=0.92 w=0.42 l=0.15
X26 a_n2549_433# out.t15 DVDD.t19 DVDD.t18 sky130_fd_pr__pfet_01v8 ad=0.105 pd=0.92 as=0.105 ps=0.92 w=0.42 l=0.15
X27 a_n1922_125# out.t16 a_n2532_125# DGND.t17 sky130_fd_pr__nfet_01v8 ad=0.105 pd=0.92 as=0.105 ps=0.92 w=0.42 l=0.15
X28 DVDD.t29 out.t17 a_n2549_433# DVDD.t28 sky130_fd_pr__pfet_01v8 ad=0.126 pd=1.44 as=0.105 ps=0.92 w=0.42 l=0.15
X29 a_n2532_125# out.t18 a_n1922_125# DGND.t16 sky130_fd_pr__nfet_01v8 ad=0.105 pd=0.92 as=0.105 ps=0.92 w=0.42 l=0.15
X30 a_n2549_433# out.t19 DVDD.t15 DVDD.t14 sky130_fd_pr__pfet_01v8 ad=0.105 pd=0.92 as=0.126 ps=1.44 w=0.42 l=0.15
X31 out.t8 B.t7 DVDD.t21 DVDD.t20 sky130_fd_pr__pfet_01v8 ad=0.105 pd=0.92 as=0.105 ps=0.92 w=0.42 l=0.15
R0 B.n0 B.t1 403.274
R1 B.n2 B.t0 366.32
R2 B.n3 B.t5 300.447
R3 B.n1 B.n0 208.868
R4 B.n4 B.n3 208.868
R5 B.n5 B.n4 208.868
R6 B.n0 B.t7 194.407
R7 B.n1 B.t2 194.407
R8 B B.n5 99.6138
R9 B.n5 B.t4 91.5805
R10 B.n4 B.t6 91.5805
R11 B.n3 B.t3 91.5805
R12 B.n2 B.n1 36.9538
R13 B B.n2 12.8538
R14 DVDD.n0 DVDD.t0 1171.34
R15 DVDD.t8 DVDD.t24 1092.5
R16 DVDD.t26 DVDD.t28 1092.5
R17 DVDD.t14 DVDD.t30 1092.5
R18 DVDD.n7 DVDD.t15 699.553
R19 DVDD.n10 DVDD.t29 699.553
R20 DVDD.n5 DVDD.t5 697.879
R21 DVDD.n6 DVDD.t31 697.567
R22 DVDD.n11 DVDD.t27 697.567
R23 DVDD.n14 DVDD.t25 697.567
R24 DVDD.n3 DVDD.t9 697.567
R25 DVDD.n0 DVDD.t1 697.567
R26 DVDD.n9 DVDD.n8 629.196
R27 DVDD.n5 DVDD.n4 627.21
R28 DVDD.n13 DVDD.n12 627.21
R29 DVDD.n2 DVDD.n1 627.21
R30 DVDD.t0 DVDD.t10 514.583
R31 DVDD.t10 DVDD.t6 514.583
R32 DVDD.t6 DVDD.t8 514.583
R33 DVDD.t24 DVDD.t20 514.583
R34 DVDD.t20 DVDD.t22 514.583
R35 DVDD.t22 DVDD.t26 514.583
R36 DVDD.t28 DVDD.t18 514.583
R37 DVDD.t18 DVDD.t16 514.583
R38 DVDD.t16 DVDD.t14 514.583
R39 DVDD.t30 DVDD.t2 514.583
R40 DVDD.t2 DVDD.t12 514.583
R41 DVDD.t12 DVDD.t4 514.583
R42 DVDD.n4 DVDD.t3 117.263
R43 DVDD.n4 DVDD.t13 117.263
R44 DVDD.n8 DVDD.t19 117.263
R45 DVDD.n8 DVDD.t17 117.263
R46 DVDD.n12 DVDD.t21 117.263
R47 DVDD.n12 DVDD.t23 117.263
R48 DVDD.n1 DVDD.t11 117.263
R49 DVDD.n1 DVDD.t7 117.263
R50 DVDD.n2 DVDD.n0 0.313
R51 DVDD.n3 DVDD.n2 0.313
R52 DVDD.n14 DVDD.n13 0.313
R53 DVDD.n13 DVDD.n11 0.313
R54 DVDD.n10 DVDD.n9 0.313
R55 DVDD.n9 DVDD.n7 0.313
R56 DVDD.n6 DVDD.n5 0.313
R57 DVDD.n11 DVDD.n10 0.242688
R58 DVDD.n7 DVDD.n6 0.242688
R59 DVDD DVDD.n3 0.16326
R60 DVDD DVDD.n14 0.0799271
R61 out.n4 out.n3 708.106
R62 out.n7 out.n1 662.178
R63 out.n6 out.n5 616.624
R64 out.n4 out.n2 610.225
R65 out.n16 out.n15 528.322
R66 out.n12 out.t19 417.733
R67 out.n10 out.t16 305.267
R68 out.n9 out.t14 305.267
R69 out out.n0 254.272
R70 out.n16 out.n8 220.012
R71 out.n14 out.t15 208.868
R72 out.n12 out.t13 208.868
R73 out.n15 out.n14 206.031
R74 out.n15 out.t17 202.44
R75 out.n11 out.n10 147.814
R76 out.n6 out.n4 146.447
R77 out.n14 out.n13 123.713
R78 out.n5 out.t1 117.263
R79 out.n5 out.t3 117.263
R80 out.n2 out.t10 117.263
R81 out.n2 out.t8 117.263
R82 out.n3 out.t9 117.263
R83 out.n3 out.t11 117.263
R84 out.n1 out.t0 117.263
R85 out.n1 out.t4 117.263
R86 out.n10 out.t18 96.4005
R87 out.n9 out.t12 96.4005
R88 out.n13 out.n11 93.1872
R89 out.n13 out.n12 85.1538
R90 out.n8 out.t5 71.4291
R91 out.n8 out.t7 71.4291
R92 out.n0 out.t6 71.4291
R93 out.n0 out.t2 71.4291
R94 out.n11 out.n9 61.0538
R95 out.n17 out.n16 56.6997
R96 out.n7 out.n6 40.2829
R97 out.n17 out.n7 25.6005
R98 out out.n17 6.77697
R99 A.n0 A.t0 417.733
R100 A.n5 A.t1 350.253
R101 A.n2 A.t6 305.267
R102 A.n4 A.t7 300.447
R103 A.n0 A.t5 208.868
R104 A.n1 A.t3 208.868
R105 A.n3 A.n2 208.868
R106 A.n1 A.n0 208.868
R107 A.n3 A.t2 96.4005
R108 A.n2 A.t4 96.4005
R109 A.n5 A.n4 93.1872
R110 A A.n1 57.8405
R111 A A.n5 9.6405
R112 A.n4 A.n3 4.8205
R113 DGND DGND.t21 5273.64
R114 DGND.t12 DGND.t18 5260.06
R115 DGND.t21 DGND.t22 1620.4
R116 DGND.t22 DGND.t23 1620.4
R117 DGND.t23 DGND.t20 1620.4
R118 DGND.t20 DGND.t10 1620.4
R119 DGND.t10 DGND.t14 1620.4
R120 DGND.t14 DGND.t8 1620.4
R121 DGND.t8 DGND.t12 1620.4
R122 DGND.t18 DGND.t19 1620.4
R123 DGND.t19 DGND.t16 1620.4
R124 DGND.t16 DGND.t17 1620.4
R125 DGND.t17 DGND.t6 1620.4
R126 DGND.t6 DGND.t4 1620.4
R127 DGND.t4 DGND.t2 1620.4
R128 DGND.t2 DGND.t0 1620.4
R129 DGND.n4 DGND.n3 227.78
R130 DGND.n6 DGND.n5 227.339
R131 DGND.n2 DGND.n0 226.438
R132 DGND.n2 DGND.n1 226.101
R133 DGND.n0 DGND.t3 71.4291
R134 DGND.n0 DGND.t1 71.4291
R135 DGND.n1 DGND.t7 71.4291
R136 DGND.n1 DGND.t5 71.4291
R137 DGND.n3 DGND.t9 71.4291
R138 DGND.n3 DGND.t13 71.4291
R139 DGND.n5 DGND.t11 71.4291
R140 DGND.n5 DGND.t15 71.4291
R141 DGND.n4 DGND.n2 1.39764
R142 DGND.n6 DGND.n4 0.339042
R143 DGND DGND.n6 0.171073
R144 B1.n0 B1.t0 417.733
R145 B1.n1 B1.t1 417.733
R146 B1.n3 B1.t3 300.447
R147 B1.n0 B1.t4 208.868
R148 B1.n1 B1.t2 208.868
R149 B1.n4 B1.n3 208.868
R150 B1.n2 B1.n0 200.833
R151 B1.n5 B1.n4 163.881
R152 B1.n5 B1.t5 136.567
R153 B1.n4 B1.t6 91.5805
R154 B1.n3 B1.t7 91.5805
R155 B1 B1.n5 53.0205
R156 B1 B1.n2 44.9872
R157 B1.n2 B1.n1 8.03383
C0 B DVDD 0.316695f
C1 a_n2532_125# B1 0.110212f
C2 out B1 0.025946f
C3 B a_n1922_125# 5.21e-20
C4 out a_n2532_125# 0.068297f
C5 B a_n2549_433# 3.18e-19
C6 B a_n1200_125# 0.108657f
C7 B A 0.025165f
C8 a_n1922_125# DVDD 0.007457f
C9 a_n2549_433# DVDD 0.374131f
C10 a_n1200_125# DVDD 0.008867f
C11 A DVDD 0.315786f
C12 a_n1922_125# a_n2549_433# 0.07988f
C13 a_n1922_125# a_n1200_125# 0.003585f
C14 a_n2549_433# A 5.31e-22
C15 a_n1200_125# A 0.05636f
C16 B a_n2532_125# 2.65e-19
C17 out B 0.147818f
C18 B1 DVDD 0.310845f
C19 a_n2532_125# DVDD 0.016363f
C20 out DVDD 0.905631f
C21 a_n1922_125# B1 1.77e-19
C22 a_n1922_125# a_n2532_125# 0.141481f
C23 a_n2549_433# B1 0.07852f
C24 out a_n1922_125# 0.099544f
C25 a_n2532_125# a_n2549_433# 0.124538f
C26 out a_n2549_433# 0.085503f
C27 a_n2532_125# a_n1200_125# 0.002854f
C28 out a_n1200_125# 0.384277f
C29 out A 0.203056f
C30 A DGND 0.654973f
C31 B DGND 0.670801f
C32 out DGND 1.33948f
C33 B1 DGND 0.716093f
C34 DVDD DGND 3.35885f
C35 a_n1200_125# DGND 0.629643f
C36 a_n1922_125# DGND 0.069077f
C37 a_n2532_125# DGND 0.645582f
C38 a_n2549_433# DGND 0.149233f
.ends
