** sch_path: /home/joyen/ee5311/EE5311/assignments/assignment4/ro7.sch
**.subckt ro7 DVDD in out DGND
*.ipin in
*.opin out
*.iopin DVDD
*.iopin DGND
x1 DVDD in net1 DGND inv
x2 DVDD net1 net2 DGND inv
x3 DVDD net2 net3 DGND inv
x4 DVDD net3 net4 DGND inv
x5 DVDD net4 net5 DGND inv
x6 DVDD net5 net6 DGND inv
x7 DVDD net6 out DGND inv
**.ends

* expanding   symbol:  inv.sym # of pins=8
** sym_path: /home/joyen/ee5311/EE5311/assignments/assignment4/inv.sym
** sch_path: /home/joyen/ee5311/EE5311/assignments/assignment4/inv.sch
.subckt inv DVDD in out DGND
*.ipin in
*.opin out
*.iopin DVDD
*.iopin DGND
XM3 out in DVDD DVDD sky130_fd_pr__pfet_01v8 L=0.15 W=0.84 nf=1 ad='int((nf+1)/2) * W/nf * 0.29' as='int((nf+2)/2) * W/nf * 0.29' pd='2*int((nf+1)/2) * (W/nf + 0.29)'
+ ps='2*int((nf+2)/2) * (W/nf + 0.29)' nrd='0.29 / W' nrs='0.29 / W' sa=0 sb=0 sd=0 mult=1
XM2 out in DGND DGND sky130_fd_pr__nfet_01v8 L=0.15 W=0.42 nf=1 ad='int((nf+1)/2) * W/nf * 0.29' as='int((nf+2)/2) * W/nf * 0.29' pd='2*int((nf+1)/2) * (W/nf + 0.29)'
+ ps='2*int((nf+2)/2) * (W/nf + 0.29)' nrd='0.29 / W' nrs='0.29 / W' sa=0 sb=0 sd=0 mult=1
.ends

.end
