* NGSPICE file created from ro7.ext - technology: sky130A

.subckt ro7 DVDD in out DGND
X0 a_n1815_125# out.t2 DVDD.t13 DVDD.t12 sky130_fd_pr__pfet_01v8 ad=0.252 pd=2.28 as=0.252 ps=2.28 w=0.84 l=0.15
X1 a_n1539_125# a_n1815_125# DGND.t11 DGND.t10 sky130_fd_pr__nfet_01v8 ad=0.126 pd=1.44 as=0.126 ps=1.44 w=0.42 l=0.15
X2 a_n1539_125# a_n1815_125# DVDD.t11 DVDD.t10 sky130_fd_pr__pfet_01v8 ad=0.252 pd=2.28 as=0.252 ps=2.28 w=0.84 l=0.15
X3 a_n1263_125# a_n1539_125# DGND.t3 DGND.t2 sky130_fd_pr__nfet_01v8 ad=0.126 pd=1.44 as=0.126 ps=1.44 w=0.42 l=0.15
X4 a_n1263_125# a_n1539_125# DVDD.t3 DVDD.t2 sky130_fd_pr__pfet_01v8 ad=0.252 pd=2.28 as=0.252 ps=2.28 w=0.84 l=0.15
X5 a_n987_125# a_n1263_125# DGND.t5 DGND.t4 sky130_fd_pr__nfet_01v8 ad=0.126 pd=1.44 as=0.126 ps=1.44 w=0.42 l=0.15
X6 a_n987_125# a_n1263_125# DVDD.t5 DVDD.t4 sky130_fd_pr__pfet_01v8 ad=0.252 pd=2.28 as=0.252 ps=2.28 w=0.84 l=0.15
X7 a_n711_125# a_n987_125# DVDD.t1 DVDD.t0 sky130_fd_pr__pfet_01v8 ad=0.252 pd=2.28 as=0.252 ps=2.28 w=0.84 l=0.15
X8 a_n711_125# a_n987_125# DGND.t1 DGND.t0 sky130_fd_pr__nfet_01v8 ad=0.126 pd=1.44 as=0.126 ps=1.44 w=0.42 l=0.15
X9 a_n435_125# a_n711_125# DGND.t9 DGND.t8 sky130_fd_pr__nfet_01v8 ad=0.126 pd=1.44 as=0.126 ps=1.44 w=0.42 l=0.15
X10 a_n435_125# a_n711_125# DVDD.t9 DVDD.t8 sky130_fd_pr__pfet_01v8 ad=0.252 pd=2.28 as=0.252 ps=2.28 w=0.84 l=0.15
X11 out.t1 a_n435_125# DGND.t7 DGND.t6 sky130_fd_pr__nfet_01v8 ad=0.126 pd=1.44 as=0.126 ps=1.44 w=0.42 l=0.15
X12 out.t0 a_n435_125# DVDD.t7 DVDD.t6 sky130_fd_pr__pfet_01v8 ad=0.252 pd=2.28 as=0.252 ps=2.28 w=0.84 l=0.15
X13 a_n1815_125# out.t3 DGND.t13 DGND.t12 sky130_fd_pr__nfet_01v8 ad=0.126 pd=1.44 as=0.126 ps=1.44 w=0.42 l=0.15
R0 out.n1 out.t0 416.031
R1 out.n0 out.t2 295.627
R2 in out.n0 273.51
R3 out.n1 out.t1 263.805
R4 out.n0 out.t3 144.601
R5 in out.n2 16.8101
R6 out.n2 out.n1 9.3005
R7 out.n2 out 0.0575652
R8 DVDD.n0 DVDD.t6 1029.84
R9 DVDD.t6 DVDD.t8 809.26
R10 DVDD.t8 DVDD.t0 809.26
R11 DVDD.t0 DVDD.t4 809.26
R12 DVDD.t4 DVDD.t2 809.26
R13 DVDD.t2 DVDD.t10 809.26
R14 DVDD.t10 DVDD.t12 809.26
R15 DVDD.n2 DVDD.t3 390.087
R16 DVDD.n3 DVDD.t5 390.087
R17 DVDD.n4 DVDD.t1 390.087
R18 DVDD.n5 DVDD.t9 390.087
R19 DVDD.n1 DVDD.t11 389.865
R20 DVDD.n0 DVDD.t7 389.644
R21 DVDD.n1 DVDD.t13 389.122
R22 DVDD.n5 DVDD.n4 0.359875
R23 DVDD.n4 DVDD.n3 0.359875
R24 DVDD.n3 DVDD.n2 0.359875
R25 DVDD.n2 DVDD.n1 0.359875
R26 DVDD DVDD.n5 0.21274
R27 DVDD DVDD.n0 0.147635
R28 DGND.n0 DGND.t6 5031.87
R29 DGND.t6 DGND.t8 3930.1
R30 DGND.t8 DGND.t0 3930.1
R31 DGND.t0 DGND.t4 3930.1
R32 DGND.t4 DGND.t2 3930.1
R33 DGND.t2 DGND.t10 3930.1
R34 DGND.t10 DGND.t12 3930.1
R35 DGND.n1 DGND.t13 272.632
R36 DGND.n1 DGND.t11 272.274
R37 DGND.n2 DGND.t3 272.274
R38 DGND.n3 DGND.t5 272.274
R39 DGND.n4 DGND.t1 272.274
R40 DGND.n5 DGND.t9 272.274
R41 DGND.n0 DGND.t7 272.274
R42 DGND.n5 DGND.n4 0.359875
R43 DGND.n4 DGND.n3 0.359875
R44 DGND.n3 DGND.n2 0.359875
R45 DGND.n2 DGND.n1 0.359875
R46 DGND DGND.n0 0.191906
R47 DGND DGND.n5 0.168469
C0 out a_n987_125# 0.061357f
C1 DVDD a_n1539_125# 0.2223f
C2 out a_n1263_125# 0.061357f
C3 a_n435_125# out 0.108f
C4 a_n711_125# a_n987_125# 0.066056f
C5 out a_n711_125# 0.061357f
C6 a_n435_125# a_n711_125# 0.066056f
C7 a_n1539_125# a_n1263_125# 0.066056f
C8 out a_n1539_125# 0.061357f
C9 DVDD a_n1815_125# 0.220192f
C10 a_n1815_125# out 0.113255f
C11 DVDD a_n987_125# 0.2223f
C12 DVDD a_n1263_125# 0.2223f
C13 DVDD out 0.587723f
C14 DVDD a_n435_125# 0.225239f
C15 DVDD a_n711_125# 0.2223f
C16 a_n1815_125# a_n1539_125# 0.066056f
C17 a_n1263_125# a_n987_125# 0.066056f
C18 out DGND 0.874933f
C19 DVDD DGND 2.85692f
C20 a_n435_125# DGND 0.326863f
C21 a_n711_125# DGND 0.310944f
C22 a_n987_125# DGND 0.310944f
C23 a_n1263_125# DGND 0.310945f
C24 a_n1539_125# DGND 0.310944f
C25 a_n1815_125# DGND 0.329257f
.ends
