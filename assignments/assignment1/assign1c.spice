** sch_path: /home/joyen/ee5311/workdir/EE5311/assignments/assignment1/assign1c.sch
**.subckt assign1c
XM1 net1 net2 GND GND sky130_fd_pr__nfet_01v8 L={Length} W={Width} nf=1 ad='int((nf+1)/2) * W/nf * 0.29' as='int((nf+2)/2) * W/nf * 0.29'
+ pd='2*int((nf+1)/2) * (W/nf + 0.29)' ps='2*int((nf+2)/2) * (W/nf + 0.29)' nrd='0.29 / W' nrs='0.29 / W' sa=0 sb=0 sd=0 mult=1
Vgs net2 GND 1.8
Vds net1 GND 1.8
**** begin user architecture code

.include sim1c.cir

.lib /cad/share/pdk/sky130B/libs.tech/combined/sky130.lib.spice tt
**** end user architecture code
**.ends
.GLOBAL GND
.end
