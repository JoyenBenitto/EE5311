* Extracted by KLayout with SKY130 LVS runset on : 29/08/2026 04:55

.SUBCKT inv
X$1 DVDD out DVDD in pfet
X$2 DGND out in DGND nfet
X$3 DVDD vias_gen
X$4 DVDD DGND tap
X$5 DGND vias_gen$1
X$6 in vias_gen$2
.ENDS inv

.SUBCKT vias_gen$2 \$1
.ENDS vias_gen$2

.SUBCKT vias_gen$1 \$1
.ENDS vias_gen$1

.SUBCKT vias_gen \$1
.ENDS vias_gen

.SUBCKT nfet \$1 \$2 \$3 DGND
XM$1 \$1 \$3 \$2 DGND sky130_fd_pr__nfet_01v8 L=0.15 W=0.42 AS=0.126 AD=0.126
+ PS=1.44 PD=1.44
.ENDS nfet

.SUBCKT pfet \$1 \$2 \$3 \$4
XM$1 \$1 \$4 \$2 \$3 sky130_fd_pr__pfet_01v8 L=0.15 W=0.84 AS=0.252 AD=0.252
+ PS=2.28 PD=2.28
.ENDS pfet

.SUBCKT tap \$1 \$2
.ENDS tap
